;; planes.il -- planos dinamicos: GND02 = GND, PWR05 = 3.3V_EXT (contorno -25 mil, sin cobre bajo los dedos: y < 200)
procedure( pl_one(lay net)
  let((r sh d)
    r = axlDBCreateShape(axlPathStart(list(list(1337.988 349.799) list(565.551 349.799) list(565.551 225.000) list(25.000 225.000) list(25.000 4173.815) list(6575.394 4173.815) list(6575.394 272.709) list(3097.048 272.709) list(3097.048 225.000) list(1796.650 225.000) list(1796.132 264.245) list(1792.218 281.890) list(1785.097 298.495) list(1775.020 313.513) list(1762.326 326.381) list(1747.487 336.680) list(1730.987 344.059) list(1713.401 348.243) list(1695.351 349.103) list(1677.442 346.595) list(1660.321 340.809) list(1644.563 331.960) list(1630.725 320.330) list(1619.274 306.349) list(1610.617 290.485) list(1605.047 273.291) list(1602.837 255.939) list(1602.949 225.000) list(1337.988 225.000) list(1337.988 349.799)) 0.0) t lay net)
    sh = car(r)
    d = sh && axlShapeChangeDynamicType(sh t t)
    printf("plano %s %s -> %L dyn %L\n" lay net r d)
    d))
procedure( pl_go()
  pl_one("ETCH/GND02" "GND")
  pl_one("ETCH/PWR05" "3.3V_EXT")
  printf("upd %L\n" axlDBDynamicShapes(t))
  printf("DRC=%L\n" axlDRCUpdate(nil))
  axlSaveDesign(?noConfirm t))
