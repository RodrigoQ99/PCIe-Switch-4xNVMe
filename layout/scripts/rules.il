;; rules.il -- paso 2: reglas (same net off, espaciado intra-par, tolerancia de fase, clase de potencia)
R2_DPS = list("DP_PET0_P0" "DP_PET0_UP" "DP_PET1_P0" "DP_PET1_UP" "DP_PET2_P0" "DP_PET2_UP" "DP_PET3_P0" "DP_PET3_UP" "DP_PET4_M2" "DP_PET4_SSD" "DP_PET5_M2" "DP_PET5_SSD" "DP_PET6_M2" "DP_PET6_SSD" "DP_PET7_M2" "DP_PET7_SSD" "DP_PER0" "DP_PER1" "DP_PER2" "DP_PER3" "DP_PER4" "DP_PER5" "DP_PER6" "DP_PER7" "DP_CREFCLK" "DP_REFCLKI_R" "DP_REFCLKO0" "DP_REFCLK_PHY0" "DP_REFCLK_PHY1" "DP_REFCLKO4" "DP_REFCLK_SL4" "DP_REFCLKO5" "DP_REFCLK_SL5" "DP_REFCLKO6" "DP_REFCLK_SL6" "DP_REFCLKO7" "DP_REFCLK_SL7")
R2_PWR = list("12VCC_EXT" "3.3V_SLOT" "3.3V_EXT" "0.95VDDC" "0.95V_VDDC" "0.95VP" "0.95V_VP" "1.8V_EXT" "1.8VDDR" "1.8VPH" "0.95C_VDDC" "0.95V_CVDDC" "1.8C_VDDR" "3.3VAUX")
procedure( r2_nc(nm) car(setof(x axlDBGetDesign()->netclass x->name == nm)))
procedure( r2_net(nm) car(setof(x axlDBGetDesign()->nets x->name == nm)))
procedure( r2_go()
  let((f nc dp pc n)
    f = outfile("rules.log" "w")
    fprintf(f "samenet off %L\n" axlCNSSameNetModeSet('all 'off))
    fprintf(f "create DIFF_SP %L\n" axlCNSCreate('spacing "DIFF_SP" nil))
    fprintf(f "DIFF_SP line_line 5 %L\n" axlCNSSetSpacing("DIFF_SP" nil 'line_line 5.0))
    foreach(nm list("DIFF_85OHM" "DIFF_85OHM_TX" "DIFF_85OHM_RX")
      nc = r2_nc(nm)
      fprintf(f "nc %s %L spc %L\n" nm nc (nc && axlDBAddProp(nc list("SPACING_CONSTRAINT_SET" "DIFF_SP")))))
    foreach(nm R2_DPS
      dp = car(axlSelectByName("DIFFPAIR" nm))
      fprintf(f "dp %s %L phase %L\n" nm dp (dp && axlDBAddProp(dp list("DIFFP_PHASE_TOL" "5 MIL")))))
    pc = r2_nc("PWR_NETS")
    unless(pc pc = axlNetClassCreate("PWR_NETS" 'physical))
    fprintf(f "PWR_NETS %L prop %L\n" pc (pc && axlDBAddProp(pc list("PHYSICAL_CONSTRAINT_SET" "PWR"))))
    foreach(nm R2_PWR
      n = r2_net(nm)
      fprintf(f "pwr %s %L %L\n" nm n (n && pc && axlNetClassAdd(pc n))))
    fprintf(f "DRC=%L\n" axlDRCUpdate(nil))
    fprintf(f "save %L\n" axlSaveDesign(?noConfirm t))
    close(f) t))
