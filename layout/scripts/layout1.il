;; layout1.il -- generado por gen_layout.py
lyLog = nil
procedure( lyMsg(m) when(lyLog fprintf(lyLog "%s\n" m) drain(lyLog)) printf("%s\n" m))

procedure( lay_open() axlOpenDesign(?design "pcie_switch_4xnvme.brd" ?mode "wf"))

procedure( lay_tech()
  axlRunBatchDBProgram("techfile" "techfile -r -q EVB_ref_tech.tcfx %s" ?logfile "techfile_in" ?reloadDB t))

procedure( lay_outline()
  let((p r)
    axlDBChangeDesignExtents(list(list(-1500.0 -1500.0) list(8000.0 5500.0)))
    p = axlPathStart(list(list(0.000 0.000) list(590.551 0.000) list(590.551 324.799) list(1312.988 324.799) list(1312.988 0.000) list(1627.949 0.000) list(1627.949 247.709) list(1627.858 254.520) list(1629.551 267.811) list(1633.681 280.559) list(1640.098 292.319) list(1648.591 302.689) list(1658.850 311.311) list(1670.531 317.870) list(1683.228 322.161) list(1696.500 324.020) list(1709.882 323.382) list(1722.921 320.280) list(1735.150 314.811) list(1746.161 307.169) list(1755.571 297.630) list(1763.039 286.500) list(1768.319 274.189) list(1771.220 261.110) list(1771.650 247.709) list(1771.650 -177.169) list(2212.598 -177.169) list(2212.598 113.331) list(2212.740 120.161) list(2215.051 129.531) list(2219.681 138.000) list(2226.319 145.020) list(2234.531 150.098) list(2243.760 152.921) list(2253.409 153.280) list(2262.831 151.169) list(2271.402 146.728) list(2278.559 140.240) list(2283.811 132.142) list(2286.831 122.969) list(2287.402 113.331) list(2287.402 -177.169) list(3122.048 -177.169) list(3122.048 247.709) list(6600.394 247.709) list(6600.394 4198.815) list(0.000 4198.815) list(0.000 0.000)) 0.0)
    r = axlDBCreateShape(p nil "BOARD GEOMETRY/DESIGN_OUTLINE")
    unless(r r = axlDBCreateShape(p nil "BOARD GEOMETRY/OUTLINE"))
    printf("outline: %L\n" r)
    r))

procedure( lay_place()
  let((n bad)
    n = 0 bad = 0
    lyLog = outfile("layout1.log" "w")
    if(axlDBCreateSymbol("BD1" list(1665.000 2620.000) nil 0.000) then n = n + 1 else bad = bad + 1 lyMsg("FALLO BD1"))
    if(axlDBCreateSymbol("BD3" list(2345.000 1845.000) nil 0.000) then n = n + 1 else bad = bad + 1 lyMsg("FALLO BD3"))
    if(axlDBCreateSymbol("BD4" list(2365.000 2620.000) nil 0.000) then n = n + 1 else bad = bad + 1 lyMsg("FALLO BD4"))
    if(axlDBCreateSymbol("BD6" list(1845.000 1545.000) nil 0.000) then n = n + 1 else bad = bad + 1 lyMsg("FALLO BD6"))
    if(axlDBCreateSymbol("BD7" list(1845.000 1355.000) nil 0.000) then n = n + 1 else bad = bad + 1 lyMsg("FALLO BD7"))
    if(axlDBCreateSymbol("BD8" list(2085.000 1880.000) nil 0.000) then n = n + 1 else bad = bad + 1 lyMsg("FALLO BD8"))
    if(axlDBCreateSymbol("C1" list(1570.000 2000.000) nil 0.000) then n = n + 1 else bad = bad + 1 lyMsg("FALLO C1"))
    if(axlDBCreateSymbol("C10" list(1950.000 2300.000) nil 0.000) then n = n + 1 else bad = bad + 1 lyMsg("FALLO C10"))
    if(axlDBCreateSymbol("C100" list(1150.000 1250.000) nil 0.000) then n = n + 1 else bad = bad + 1 lyMsg("FALLO C100"))
    if(axlDBCreateSymbol("C101" list(1450.000 1175.000) nil 0.000) then n = n + 1 else bad = bad + 1 lyMsg("FALLO C101"))
    if(axlDBCreateSymbol("C102" list(1450.000 925.000) nil 0.000) then n = n + 1 else bad = bad + 1 lyMsg("FALLO C102"))
    if(axlDBCreateSymbol("C103" list(815.000 1645.000) nil 0.000) then n = n + 1 else bad = bad + 1 lyMsg("FALLO C103"))
    if(axlDBCreateSymbol("C104" list(1600.000 1050.000) nil 0.000) then n = n + 1 else bad = bad + 1 lyMsg("FALLO C104"))
    if(axlDBCreateSymbol("C106" list(1305.000 1080.000) nil 0.000) then n = n + 1 else bad = bad + 1 lyMsg("FALLO C106"))
    if(axlDBCreateSymbol("C107" list(1580.000 1170.000) nil 0.000) then n = n + 1 else bad = bad + 1 lyMsg("FALLO C107"))
    if(axlDBCreateSymbol("C108" list(1300.000 960.000) nil 0.000) then n = n + 1 else bad = bad + 1 lyMsg("FALLO C108"))
    if(axlDBCreateSymbol("C109" list(685.000 1645.000) nil 0.000) then n = n + 1 else bad = bad + 1 lyMsg("FALLO C109"))
    if(axlDBCreateSymbol("C11" list(1305.000 2360.000) nil 0.000) then n = n + 1 else bad = bad + 1 lyMsg("FALLO C11"))
    if(axlDBCreateSymbol("C110" list(355.000 1315.000) nil 0.000) then n = n + 1 else bad = bad + 1 lyMsg("FALLO C110"))
    if(axlDBCreateSymbol("C111" list(355.000 1185.000) nil 0.000) then n = n + 1 else bad = bad + 1 lyMsg("FALLO C111"))
    if(axlDBCreateSymbol("C112" list(2010.000 890.000) nil 0.000) then n = n + 1 else bad = bad + 1 lyMsg("FALLO C112"))
    if(axlDBCreateSymbol("C113" list(1580.000 930.000) nil 0.000) then n = n + 1 else bad = bad + 1 lyMsg("FALLO C113"))
    if(axlDBCreateSymbol("C114" list(1290.000 1170.000) nil 0.000) then n = n + 1 else bad = bad + 1 lyMsg("FALLO C114"))
    if(axlDBCreateSymbol("C115" list(1450.000 850.000) nil 0.000) then n = n + 1 else bad = bad + 1 lyMsg("FALLO C115"))
    if(axlDBCreateSymbol("C116" list(685.000 855.000) nil 0.000) then n = n + 1 else bad = bad + 1 lyMsg("FALLO C116"))
    if(axlDBCreateSymbol("C117" list(815.000 855.000) nil 0.000) then n = n + 1 else bad = bad + 1 lyMsg("FALLO C117"))
    if(axlDBCreateSymbol("C118" list(1155.000 1375.000) nil 0.000) then n = n + 1 else bad = bad + 1 lyMsg("FALLO C118"))
    if(axlDBCreateSymbol("C119" list(2660.000 1450.000) nil 0.000) then n = n + 1 else bad = bad + 1 lyMsg("FALLO C119"))
    if(axlDBCreateSymbol("C12" list(1930.000 2425.000) nil 0.000) then n = n + 1 else bad = bad + 1 lyMsg("FALLO C12"))
    if(axlDBCreateSymbol("C120" list(2283.871 1548.220) t 180.000) then n = n + 1 else bad = bad + 1 lyMsg("FALLO C120"))
    if(axlDBCreateSymbol("C121" list(2244.511 1508.860) t 0.000) then n = n + 1 else bad = bad + 1 lyMsg("FALLO C121"))
    if(axlDBCreateSymbol("C122" list(2244.511 1469.500) t 180.000) then n = n + 1 else bad = bad + 1 lyMsg("FALLO C122"))
    if(axlDBCreateSymbol("C123" list(2778.551 1382.700) t 270.000) then n = n + 1 else bad = bad + 1 lyMsg("FALLO C123"))
    if(axlDBCreateSymbol("C124" list(2658.551 1362.700) t 270.000) then n = n + 1 else bad = bad + 1 lyMsg("FALLO C124"))
    if(axlDBCreateSymbol("C125" list(2283.871 1390.780) t 180.000) then n = n + 1 else bad = bad + 1 lyMsg("FALLO C125"))
    if(axlDBCreateSymbol("C126" list(2205.151 1430.140) t 0.000) then n = n + 1 else bad = bad + 1 lyMsg("FALLO C126"))
    if(axlDBCreateSymbol("C127" list(2665.000 1575.000) nil 0.000) then n = n + 1 else bad = bad + 1 lyMsg("FALLO C127"))
    if(axlDBCreateSymbol("C128" list(2205.151 1548.220) t 180.000) then n = n + 1 else bad = bad + 1 lyMsg("FALLO C128"))
    if(axlDBCreateSymbol("C129" list(2323.231 1469.500) t 180.000) then n = n + 1 else bad = bad + 1 lyMsg("FALLO C129"))
    if(axlDBCreateSymbol("C13" list(1405.000 2590.000) nil 0.000) then n = n + 1 else bad = bad + 1 lyMsg("FALLO C13"))
    if(axlDBCreateSymbol("C130" list(2205.151 1390.780) t 180.000) then n = n + 1 else bad = bad + 1 lyMsg("FALLO C130"))
    if(axlDBCreateSymbol("C131" list(2603.551 1812.700) t 90.000) then n = n + 1 else bad = bad + 1 lyMsg("FALLO C131"))
    if(axlDBCreateSymbol("C132" list(2428.551 1762.700) t 180.000) then n = n + 1 else bad = bad + 1 lyMsg("FALLO C132"))
    if(axlDBCreateSymbol("C133" list(2283.871 1430.140) t 0.000) then n = n + 1 else bad = bad + 1 lyMsg("FALLO C133"))
    if(axlDBCreateSymbol("C134" list(2323.231 1508.860) t 0.000) then n = n + 1 else bad = bad + 1 lyMsg("FALLO C134"))
    if(axlDBCreateSymbol("C135" list(2465.000 1095.000) nil 0.000) then n = n + 1 else bad = bad + 1 lyMsg("FALLO C135"))
    if(axlDBCreateSymbol("C136" list(2362.591 1351.420) t 180.000) then n = n + 1 else bad = bad + 1 lyMsg("FALLO C136"))
    if(axlDBCreateSymbol("C137" list(2421.631 1371.100) t 90.000) then n = n + 1 else bad = bad + 1 lyMsg("FALLO C137"))
    if(axlDBCreateSymbol("C138" list(2715.000 1325.000) nil 0.000) then n = n + 1 else bad = bad + 1 lyMsg("FALLO C138"))
    if(axlDBCreateSymbol("C139" list(2565.000 1830.000) nil 0.000) then n = n + 1 else bad = bad + 1 lyMsg("FALLO C139"))
    if(axlDBCreateSymbol("C14" list(1305.000 2240.000) nil 0.000) then n = n + 1 else bad = bad + 1 lyMsg("FALLO C14"))
    if(axlDBCreateSymbol("C140" list(2146.111 1489.180) t 90.000) then n = n + 1 else bad = bad + 1 lyMsg("FALLO C140"))
    if(axlDBCreateSymbol("C141" list(2165.791 1351.420) t 180.000) then n = n + 1 else bad = bad + 1 lyMsg("FALLO C141"))
    if(axlDBCreateSymbol("C142" list(2185.471 1489.180) t 90.000) then n = n + 1 else bad = bad + 1 lyMsg("FALLO C142"))
    if(axlDBCreateSymbol("C143" list(2146.111 1410.460) t 90.000) then n = n + 1 else bad = bad + 1 lyMsg("FALLO C143"))
    if(axlDBCreateSymbol("C144" list(2763.551 1837.700) t 90.000) then n = n + 1 else bad = bad + 1 lyMsg("FALLO C144"))
    if(axlDBCreateSymbol("C145" list(2673.551 1837.700) t 90.000) then n = n + 1 else bad = bad + 1 lyMsg("FALLO C145"))
    if(axlDBCreateSymbol("C146" list(2598.551 1362.700) t 270.000) then n = n + 1 else bad = bad + 1 lyMsg("FALLO C146"))
    if(axlDBCreateSymbol("C147" list(2382.271 1489.180) t 270.000) then n = n + 1 else bad = bad + 1 lyMsg("FALLO C147"))
    if(axlDBCreateSymbol("C148" list(2362.591 1548.220) t 180.000) then n = n + 1 else bad = bad + 1 lyMsg("FALLO C148"))
    if(axlDBCreateSymbol("C149" list(2362.591 1430.140) t 180.000) then n = n + 1 else bad = bad + 1 lyMsg("FALLO C149"))
    if(axlDBCreateSymbol("C15" list(1725.000 2000.000) nil 0.000) then n = n + 1 else bad = bad + 1 lyMsg("FALLO C15"))
    if(axlDBCreateSymbol("C150" list(2898.551 1287.700) t 270.000) then n = n + 1 else bad = bad + 1 lyMsg("FALLO C150"))
    if(axlDBCreateSymbol("C151" list(2401.951 1272.700) t 180.000) then n = n + 1 else bad = bad + 1 lyMsg("FALLO C151"))
    if(axlDBCreateSymbol("C152" list(2401.951 1626.940) t 180.000) then n = n + 1 else bad = bad + 1 lyMsg("FALLO C152"))
    if(axlDBCreateSymbol("C153" list(2401.951 1312.060) t 180.000) then n = n + 1 else bad = bad + 1 lyMsg("FALLO C153"))
    if(axlDBCreateSymbol("C154" list(2106.751 1567.900) t 270.000) then n = n + 1 else bad = bad + 1 lyMsg("FALLO C154"))
    if(axlDBCreateSymbol("C155" list(2695.000 1690.000) nil 0.000) then n = n + 1 else bad = bad + 1 lyMsg("FALLO C155"))
    if(axlDBCreateSymbol("C156" list(2087.071 1312.060) t 180.000) then n = n + 1 else bad = bad + 1 lyMsg("FALLO C156"))
    if(axlDBCreateSymbol("C157" list(2087.071 1626.940) t 180.000) then n = n + 1 else bad = bad + 1 lyMsg("FALLO C157"))
    if(axlDBCreateSymbol("C158" list(2401.951 1587.580) t 180.000) then n = n + 1 else bad = bad + 1 lyMsg("FALLO C158"))
    if(axlDBCreateSymbol("C159" list(2106.751 1371.100) t 90.000) then n = n + 1 else bad = bad + 1 lyMsg("FALLO C159"))
    if(axlDBCreateSymbol("C16" list(1930.000 2175.000) nil 0.000) then n = n + 1 else bad = bad + 1 lyMsg("FALLO C16"))
    if(axlDBCreateSymbol("C160" list(2005.000 1095.000) nil 0.000) then n = n + 1 else bad = bad + 1 lyMsg("FALLO C160"))
    if(axlDBCreateSymbol("C161" list(2382.271 1174.300) t 90.000) then n = n + 1 else bad = bad + 1 lyMsg("FALLO C161"))
    if(axlDBCreateSymbol("C162" list(2421.631 1174.300) t 90.000) then n = n + 1 else bad = bad + 1 lyMsg("FALLO C162"))
    if(axlDBCreateSymbol("C163" list(1890.000 1720.000) nil 0.000) then n = n + 1 else bad = bad + 1 lyMsg("FALLO C163"))
    if(axlDBCreateSymbol("C164" list(2224.831 1253.020) t 270.000) then n = n + 1 else bad = bad + 1 lyMsg("FALLO C164"))
    if(axlDBCreateSymbol("C165" list(2224.831 1607.260) t 90.000) then n = n + 1 else bad = bad + 1 lyMsg("FALLO C165"))
    if(axlDBCreateSymbol("C166" list(2264.191 1607.260) t 90.000) then n = n + 1 else bad = bad + 1 lyMsg("FALLO C166"))
    if(axlDBCreateSymbol("C167" list(2224.831 1331.740) t 90.000) then n = n + 1 else bad = bad + 1 lyMsg("FALLO C167"))
    if(axlDBCreateSymbol("C17" list(1285.000 2450.000) nil 0.000) then n = n + 1 else bad = bad + 1 lyMsg("FALLO C17"))
    if(axlDBCreateSymbol("C18" list(1285.000 2150.000) nil 0.000) then n = n + 1 else bad = bad + 1 lyMsg("FALLO C18"))
    if(axlDBCreateSymbol("C19" list(1365.000 1975.000) nil 0.000) then n = n + 1 else bad = bad + 1 lyMsg("FALLO C19"))
    if(axlDBCreateSymbol("C2" list(1910.000 2590.000) nil 0.000) then n = n + 1 else bad = bad + 1 lyMsg("FALLO C2"))
    if(axlDBCreateSymbol("C20" list(1430.000 2715.000) nil 0.000) then n = n + 1 else bad = bad + 1 lyMsg("FALLO C20"))
    if(axlDBCreateSymbol("C21" list(1150.000 2330.000) nil 0.000) then n = n + 1 else bad = bad + 1 lyMsg("FALLO C21"))
    if(axlDBCreateSymbol("C22" list(980.000 1665.000) nil 0.000) then n = n + 1 else bad = bad + 1 lyMsg("FALLO C22"))
    if(axlDBCreateSymbol("C23" list(980.000 835.000) nil 0.000) then n = n + 1 else bad = bad + 1 lyMsg("FALLO C23"))
    if(axlDBCreateSymbol("C24" list(1190.000 1490.000) nil 0.000) then n = n + 1 else bad = bad + 1 lyMsg("FALLO C24"))
    if(axlDBCreateSymbol("C244" list(365.000 1435.000) nil 0.000) then n = n + 1 else bad = bad + 1 lyMsg("FALLO C244"))
    if(axlDBCreateSymbol("C245" list(365.000 1065.000) nil 0.000) then n = n + 1 else bad = bad + 1 lyMsg("FALLO C245"))
    if(axlDBCreateSymbol("C25" list(780.000 1750.000) nil 0.000) then n = n + 1 else bad = bad + 1 lyMsg("FALLO C25"))
    if(axlDBCreateSymbol("C26" list(480.000 1670.000) nil 0.000) then n = n + 1 else bad = bad + 1 lyMsg("FALLO C26"))
    if(axlDBCreateSymbol("C27" list(440.000 795.000) nil 0.000) then n = n + 1 else bad = bad + 1 lyMsg("FALLO C27"))
    if(axlDBCreateSymbol("C28" list(1795.000 1895.000) nil 0.000) then n = n + 1 else bad = bad + 1 lyMsg("FALLO C28"))
    if(axlDBCreateSymbol("C29" list(1725.000 2810.000) nil 0.000) then n = n + 1 else bad = bad + 1 lyMsg("FALLO C29"))
    if(axlDBCreateSymbol("C3" list(1345.000 1815.000) nil 0.000) then n = n + 1 else bad = bad + 1 lyMsg("FALLO C3"))
    if(axlDBCreateSymbol("C30" list(1850.000 2020.000) nil 0.000) then n = n + 1 else bad = bad + 1 lyMsg("FALLO C30"))
    if(axlDBCreateSymbol("C31" list(1195.000 2595.000) nil 0.000) then n = n + 1 else bad = bad + 1 lyMsg("FALLO C31"))
    if(axlDBCreateSymbol("C32" list(2220.000 2035.000) nil 0.000) then n = n + 1 else bad = bad + 1 lyMsg("FALLO C32"))
    if(axlDBCreateSymbol("C33" list(2395.000 2015.000) nil 0.000) then n = n + 1 else bad = bad + 1 lyMsg("FALLO C33"))
    if(axlDBCreateSymbol("C34" list(2330.000 2800.000) nil 0.000) then n = n + 1 else bad = bad + 1 lyMsg("FALLO C34"))
    if(axlDBCreateSymbol("C35" list(2600.000 2300.000) nil 0.000) then n = n + 1 else bad = bad + 1 lyMsg("FALLO C35"))
    if(axlDBCreateSymbol("C36" list(720.000 750.000) nil 0.000) then n = n + 1 else bad = bad + 1 lyMsg("FALLO C36"))
    if(axlDBCreateSymbol("C37" list(1135.000 1065.000) nil 0.000) then n = n + 1 else bad = bad + 1 lyMsg("FALLO C37"))
    if(axlDBCreateSymbol("C38" list(1450.000 1425.000) nil 0.000) then n = n + 1 else bad = bad + 1 lyMsg("FALLO C38"))
    if(axlDBCreateSymbol("C39" list(1600.000 1300.000) nil 0.000) then n = n + 1 else bad = bad + 1 lyMsg("FALLO C39"))
    if(axlDBCreateSymbol("C4" list(1600.000 1900.000) nil 0.000) then n = n + 1 else bad = bad + 1 lyMsg("FALLO C4"))
    if(axlDBCreateSymbol("C40" list(1305.000 1330.000) nil 0.000) then n = n + 1 else bad = bad + 1 lyMsg("FALLO C40"))
    if(axlDBCreateSymbol("C41" list(580.000 1800.000) nil 0.000) then n = n + 1 else bad = bad + 1 lyMsg("FALLO C41"))
    if(axlDBCreateSymbol("C42" list(360.000 1520.000) nil 0.000) then n = n + 1 else bad = bad + 1 lyMsg("FALLO C42"))
    if(axlDBCreateSymbol("C43" list(1305.000 880.000) nil 0.000) then n = n + 1 else bad = bad + 1 lyMsg("FALLO C43"))
    if(axlDBCreateSymbol("C44" list(1290.000 1245.000) nil 0.000) then n = n + 1 else bad = bad + 1 lyMsg("FALLO C44"))
    if(axlDBCreateSymbol("C45" list(1585.000 840.000) nil 0.000) then n = n + 1 else bad = bad + 1 lyMsg("FALLO C45"))
    if(axlDBCreateSymbol("C46" list(2467.205 394.866) t 90.000) then n = n + 1 else bad = bad + 1 lyMsg("FALLO C46"))
    if(axlDBCreateSymbol("C47" list(2507.205 394.866) t 90.000) then n = n + 1 else bad = bad + 1 lyMsg("FALLO C47"))
    if(axlDBCreateSymbol("C48" list(2664.056 394.866) t 90.000) then n = n + 1 else bad = bad + 1 lyMsg("FALLO C48"))
    if(axlDBCreateSymbol("C49" list(2704.056 394.866) t 90.000) then n = n + 1 else bad = bad + 1 lyMsg("FALLO C49"))
    if(axlDBCreateSymbol("C5" list(1175.000 2455.000) nil 0.000) then n = n + 1 else bad = bad + 1 lyMsg("FALLO C5"))
    if(axlDBCreateSymbol("C50" list(2821.536 394.866) t 90.000) then n = n + 1 else bad = bad + 1 lyMsg("FALLO C50"))
    if(axlDBCreateSymbol("C51" list(2861.536 394.866) t 90.000) then n = n + 1 else bad = bad + 1 lyMsg("FALLO C51"))
    if(axlDBCreateSymbol("C52" list(2078.866 390.181) nil 0.000) then n = n + 1 else bad = bad + 1 lyMsg("FALLO C52"))
    if(axlDBCreateSymbol("C53" list(2078.866 380.181) t 180.000) then n = n + 1 else bad = bad + 1 lyMsg("FALLO C53"))
    if(axlDBCreateSymbol("C54" list(2078.866 425.181) t 180.000) then n = n + 1 else bad = bad + 1 lyMsg("FALLO C54"))
    if(axlDBCreateSymbol("C55" list(2979.016 394.866) t 90.000) then n = n + 1 else bad = bad + 1 lyMsg("FALLO C55"))
    if(axlDBCreateSymbol("C56" list(3019.016 394.866) t 90.000) then n = n + 1 else bad = bad + 1 lyMsg("FALLO C56"))
    if(axlDBCreateSymbol("C6" list(1135.000 2205.000) nil 0.000) then n = n + 1 else bad = bad + 1 lyMsg("FALLO C6"))
    if(axlDBCreateSymbol("C7" list(1050.000 2055.000) nil 0.000) then n = n + 1 else bad = bad + 1 lyMsg("FALLO C7"))
    if(axlDBCreateSymbol("C741" list(3290.000 1000.000) nil 0.000) then n = n + 1 else bad = bad + 1 lyMsg("FALLO C741"))
    if(axlDBCreateSymbol("C742" list(3290.000 1075.000) nil 0.000) then n = n + 1 else bad = bad + 1 lyMsg("FALLO C742"))
    if(axlDBCreateSymbol("C743" list(3260.000 905.000) nil 0.000) then n = n + 1 else bad = bad + 1 lyMsg("FALLO C743"))
    if(axlDBCreateSymbol("C744" list(3440.000 1000.000) nil 0.000) then n = n + 1 else bad = bad + 1 lyMsg("FALLO C744"))
    if(axlDBCreateSymbol("C745" list(3180.000 1060.000) nil 0.000) then n = n + 1 else bad = bad + 1 lyMsg("FALLO C745"))
    if(axlDBCreateSymbol("C746" list(3275.000 1150.000) nil 0.000) then n = n + 1 else bad = bad + 1 lyMsg("FALLO C746"))
    if(axlDBCreateSymbol("C751" list(4235.000 1000.000) nil 0.000) then n = n + 1 else bad = bad + 1 lyMsg("FALLO C751"))
    if(axlDBCreateSymbol("C752" list(4235.000 1075.000) nil 0.000) then n = n + 1 else bad = bad + 1 lyMsg("FALLO C752"))
    if(axlDBCreateSymbol("C753" list(4205.000 905.000) nil 0.000) then n = n + 1 else bad = bad + 1 lyMsg("FALLO C753"))
    if(axlDBCreateSymbol("C754" list(4385.000 1000.000) nil 0.000) then n = n + 1 else bad = bad + 1 lyMsg("FALLO C754"))
    if(axlDBCreateSymbol("C755" list(4125.000 1060.000) nil 0.000) then n = n + 1 else bad = bad + 1 lyMsg("FALLO C755"))
    if(axlDBCreateSymbol("C756" list(4220.000 1150.000) nil 0.000) then n = n + 1 else bad = bad + 1 lyMsg("FALLO C756"))
    if(axlDBCreateSymbol("C761" list(5180.000 1000.000) nil 0.000) then n = n + 1 else bad = bad + 1 lyMsg("FALLO C761"))
    if(axlDBCreateSymbol("C762" list(5180.000 1075.000) nil 0.000) then n = n + 1 else bad = bad + 1 lyMsg("FALLO C762"))
    if(axlDBCreateSymbol("C763" list(5150.000 905.000) nil 0.000) then n = n + 1 else bad = bad + 1 lyMsg("FALLO C763"))
    if(axlDBCreateSymbol("C764" list(5330.000 1000.000) nil 0.000) then n = n + 1 else bad = bad + 1 lyMsg("FALLO C764"))
    if(axlDBCreateSymbol("C765" list(5070.000 1060.000) nil 0.000) then n = n + 1 else bad = bad + 1 lyMsg("FALLO C765"))
    if(axlDBCreateSymbol("C766" list(5165.000 1150.000) nil 0.000) then n = n + 1 else bad = bad + 1 lyMsg("FALLO C766"))
    if(axlDBCreateSymbol("C771" list(6125.000 1000.000) nil 0.000) then n = n + 1 else bad = bad + 1 lyMsg("FALLO C771"))
    if(axlDBCreateSymbol("C772" list(6125.000 1075.000) nil 0.000) then n = n + 1 else bad = bad + 1 lyMsg("FALLO C772"))
    if(axlDBCreateSymbol("C773" list(6095.000 905.000) nil 0.000) then n = n + 1 else bad = bad + 1 lyMsg("FALLO C773"))
    if(axlDBCreateSymbol("C774" list(6275.000 1000.000) nil 0.000) then n = n + 1 else bad = bad + 1 lyMsg("FALLO C774"))
    if(axlDBCreateSymbol("C775" list(6015.000 1060.000) nil 0.000) then n = n + 1 else bad = bad + 1 lyMsg("FALLO C775"))
    if(axlDBCreateSymbol("C776" list(6110.000 1150.000) nil 0.000) then n = n + 1 else bad = bad + 1 lyMsg("FALLO C776"))
    if(axlDBCreateSymbol("C8" list(1430.000 2850.000) nil 0.000) then n = n + 1 else bad = bad + 1 lyMsg("FALLO C8"))
    if(axlDBCreateSymbol("C9" list(1980.000 2060.000) nil 0.000) then n = n + 1 else bad = bad + 1 lyMsg("FALLO C9"))
    if(axlDBCreateSymbol("C99" list(1725.000 1050.000) nil 0.000) then n = n + 1 else bad = bad + 1 lyMsg("FALLO C99"))
    if(axlDBCreateSymbol("DS1" list(2185.000 930.000) nil 0.000) then n = n + 1 else bad = bad + 1 lyMsg("FALLO DS1"))
    if(axlDBCreateSymbol("DS2" list(2355.000 910.000) nil 0.000) then n = n + 1 else bad = bad + 1 lyMsg("FALLO DS2"))
    if(axlDBCreateSymbol("DS3" list(1980.000 990.000) nil 0.000) then n = n + 1 else bad = bad + 1 lyMsg("FALLO DS3"))
    if(axlDBCreateSymbol("DS4" list(2240.000 795.000) nil 0.000) then n = n + 1 else bad = bad + 1 lyMsg("FALLO DS4"))
    if(axlDBCreateSymbol("DS5" list(2530.000 975.000) nil 0.000) then n = n + 1 else bad = bad + 1 lyMsg("FALLO DS5"))
    if(axlDBCreateSymbol("J44" list(2925.827 700.000) nil 180.000) then n = n + 1 else bad = bad + 1 lyMsg("FALLO J44"))
    if(axlDBCreateSymbol("J45" list(3870.827 700.000) nil 180.000) then n = n + 1 else bad = bad + 1 lyMsg("FALLO J45"))
    if(axlDBCreateSymbol("J46" list(4815.827 700.000) nil 180.000) then n = n + 1 else bad = bad + 1 lyMsg("FALLO J46"))
    if(axlDBCreateSymbol("J47" list(5760.827 700.000) nil 180.000) then n = n + 1 else bad = bad + 1 lyMsg("FALLO J47"))
    if(axlDBCreateSymbol("P2" list(2250.979 -177.160) nil 0.000) then n = n + 1 else bad = bad + 1 lyMsg("FALLO P2"))
    if(axlDBCreateSymbol("PWR1" list(600.000 3631.571) nil 0.000) then n = n + 1 else bad = bad + 1 lyMsg("FALLO PWR1"))
    if(axlDBCreateSymbol("Q1" list(2190.000 1065.000) nil 0.000) then n = n + 1 else bad = bad + 1 lyMsg("FALLO Q1"))
    if(axlDBCreateSymbol("Q2" list(2340.000 1035.000) nil 0.000) then n = n + 1 else bad = bad + 1 lyMsg("FALLO Q2"))
    if(axlDBCreateSymbol("R1" list(1250.000 2695.000) nil 0.000) then n = n + 1 else bad = bad + 1 lyMsg("FALLO R1"))
    if(axlDBCreateSymbol("R10" list(360.000 980.000) nil 0.000) then n = n + 1 else bad = bad + 1 lyMsg("FALLO R10"))
    if(axlDBCreateSymbol("R102" list(2264.191 1193.980) t 0.000) then n = n + 1 else bad = bad + 1 lyMsg("FALLO R102"))
    if(axlDBCreateSymbol("R11" list(1725.000 1790.000) nil 0.000) then n = n + 1 else bad = bad + 1 lyMsg("FALLO R11"))
    if(axlDBCreateSymbol("R12" list(2065.000 2595.000) nil 0.000) then n = n + 1 else bad = bad + 1 lyMsg("FALLO R12"))
    if(axlDBCreateSymbol("R13" list(1155.000 955.000) nil 0.000) then n = n + 1 else bad = bad + 1 lyMsg("FALLO R13"))
    if(axlDBCreateSymbol("R135" list(2775.000 3650.000) nil 0.000) then n = n + 1 else bad = bad + 1 lyMsg("FALLO R135"))
    if(axlDBCreateSymbol("R139" list(1890.000 890.000) nil 0.000) then n = n + 1 else bad = bad + 1 lyMsg("FALLO R139"))
    if(axlDBCreateSymbol("R14" list(1145.000 1600.000) nil 0.000) then n = n + 1 else bad = bad + 1 lyMsg("FALLO R14"))
    if(axlDBCreateSymbol("R143" list(2680.000 3425.000) nil 0.000) then n = n + 1 else bad = bad + 1 lyMsg("FALLO R143"))
    if(axlDBCreateSymbol("R144" list(2435.000 3265.000) nil 0.000) then n = n + 1 else bad = bad + 1 lyMsg("FALLO R144"))
    if(axlDBCreateSymbol("R148" list(2435.000 3135.000) nil 0.000) then n = n + 1 else bad = bad + 1 lyMsg("FALLO R148"))
    if(axlDBCreateSymbol("R152" list(2620.000 2975.000) nil 0.000) then n = n + 1 else bad = bad + 1 lyMsg("FALLO R152"))
    if(axlDBCreateSymbol("R153" list(3420.000 1120.000) nil 0.000) then n = n + 1 else bad = bad + 1 lyMsg("FALLO R153"))
    if(axlDBCreateSymbol("R154" list(4365.000 1120.000) nil 0.000) then n = n + 1 else bad = bad + 1 lyMsg("FALLO R154"))
    if(axlDBCreateSymbol("R155" list(5310.000 1120.000) nil 0.000) then n = n + 1 else bad = bad + 1 lyMsg("FALLO R155"))
    if(axlDBCreateSymbol("R156" list(6255.000 1120.000) nil 0.000) then n = n + 1 else bad = bad + 1 lyMsg("FALLO R156"))
    if(axlDBCreateSymbol("R157" list(2665.000 1210.000) nil 0.000) then n = n + 1 else bad = bad + 1 lyMsg("FALLO R157"))
    if(axlDBCreateSymbol("R158" list(1860.000 1235.000) nil 0.000) then n = n + 1 else bad = bad + 1 lyMsg("FALLO R158"))
    if(axlDBCreateSymbol("R159" list(2785.000 1450.000) nil 0.000) then n = n + 1 else bad = bad + 1 lyMsg("FALLO R159"))
    if(axlDBCreateSymbol("R16" list(240.000 1375.000) nil 0.000) then n = n + 1 else bad = bad + 1 lyMsg("FALLO R16"))
    if(axlDBCreateSymbol("R160" list(1880.000 1155.000) nil 0.000) then n = n + 1 else bad = bad + 1 lyMsg("FALLO R160"))
    if(axlDBCreateSymbol("R17" list(225.000 1250.000) nil 0.000) then n = n + 1 else bad = bad + 1 lyMsg("FALLO R17"))
    if(axlDBCreateSymbol("R18" list(240.000 1125.000) nil 0.000) then n = n + 1 else bad = bad + 1 lyMsg("FALLO R18"))
    if(axlDBCreateSymbol("R19" list(245.000 1465.000) nil 0.000) then n = n + 1 else bad = bad + 1 lyMsg("FALLO R19"))
    if(axlDBCreateSymbol("R2" list(1985.000 2695.000) nil 0.000) then n = n + 1 else bad = bad + 1 lyMsg("FALLO R2"))
    if(axlDBCreateSymbol("R20" list(2600.000 2425.000) nil 0.000) then n = n + 1 else bad = bad + 1 lyMsg("FALLO R20"))
    if(axlDBCreateSymbol("R21" list(2175.000 2600.000) nil 0.000) then n = n + 1 else bad = bad + 1 lyMsg("FALLO R21"))
    if(axlDBCreateSymbol("R22" list(2600.000 2175.000) nil 0.000) then n = n + 1 else bad = bad + 1 lyMsg("FALLO R22"))
    if(axlDBCreateSymbol("R23" list(2105.000 2010.000) nil 0.000) then n = n + 1 else bad = bad + 1 lyMsg("FALLO R23"))
    if(axlDBCreateSymbol("R24" list(2590.000 2535.000) nil 0.000) then n = n + 1 else bad = bad + 1 lyMsg("FALLO R24"))
    if(axlDBCreateSymbol("R25" list(1580.000 1420.000) nil 0.000) then n = n + 1 else bad = bad + 1 lyMsg("FALLO R25"))
    if(axlDBCreateSymbol("R26" list(1480.000 1525.000) nil 0.000) then n = n + 1 else bad = bad + 1 lyMsg("FALLO R26"))
    if(axlDBCreateSymbol("R27" list(1695.000 1175.000) nil 0.000) then n = n + 1 else bad = bad + 1 lyMsg("FALLO R27"))
    if(axlDBCreateSymbol("R28" list(1435.000 775.000) nil 0.000) then n = n + 1 else bad = bad + 1 lyMsg("FALLO R28"))
    if(axlDBCreateSymbol("R29" list(1928.866 394.866) nil 270.000) then n = n + 1 else bad = bad + 1 lyMsg("FALLO R29"))
    if(axlDBCreateSymbol("R3" list(1045.000 2455.000) nil 0.000) then n = n + 1 else bad = bad + 1 lyMsg("FALLO R3"))
    if(axlDBCreateSymbol("R30" list(1973.866 394.866) nil 270.000) then n = n + 1 else bad = bad + 1 lyMsg("FALLO R30"))
    if(axlDBCreateSymbol("R4" list(1955.000 2785.000) nil 0.000) then n = n + 1 else bad = bad + 1 lyMsg("FALLO R4"))
    if(axlDBCreateSymbol("R48" list(2702.866 1489.534) t 0.000) then n = n + 1 else bad = bad + 1 lyMsg("FALLO R48"))
    if(axlDBCreateSymbol("R5" list(1245.000 2785.000) nil 0.000) then n = n + 1 else bad = bad + 1 lyMsg("FALLO R5"))
    if(axlDBCreateSymbol("R51" list(2605.000 1065.000) nil 0.000) then n = n + 1 else bad = bad + 1 lyMsg("FALLO R51"))
    if(axlDBCreateSymbol("R52" list(1880.000 1080.000) nil 0.000) then n = n + 1 else bad = bad + 1 lyMsg("FALLO R52"))
    if(axlDBCreateSymbol("R54" list(2775.000 1205.000) nil 0.000) then n = n + 1 else bad = bad + 1 lyMsg("FALLO R54"))
    if(axlDBCreateSymbol("R55" list(2740.000 1805.000) nil 0.000) then n = n + 1 else bad = bad + 1 lyMsg("FALLO R55"))
    if(axlDBCreateSymbol("R59" list(2600.000 1930.000) nil 0.000) then n = n + 1 else bad = bad + 1 lyMsg("FALLO R59"))
    if(axlDBCreateSymbol("R6" list(245.000 1035.000) nil 0.000) then n = n + 1 else bad = bad + 1 lyMsg("FALLO R6"))
    if(axlDBCreateSymbol("R7" list(920.000 725.000) nil 0.000) then n = n + 1 else bad = bad + 1 lyMsg("FALLO R7"))
    if(axlDBCreateSymbol("R72" list(1750.000 1665.000) nil 0.000) then n = n + 1 else bad = bad + 1 lyMsg("FALLO R72"))
    if(axlDBCreateSymbol("R74" list(1890.000 510.000) nil 0.000) then n = n + 1 else bad = bad + 1 lyMsg("FALLO R74"))
    if(axlDBCreateSymbol("R79" list(2740.000 1095.000) nil 0.000) then n = n + 1 else bad = bad + 1 lyMsg("FALLO R79"))
    if(axlDBCreateSymbol("R8" list(1135.000 855.000) nil 0.000) then n = n + 1 else bad = bad + 1 lyMsg("FALLO R8"))
    if(axlDBCreateSymbol("R88" list(2560.000 2010.000) nil 0.000) then n = n + 1 else bad = bad + 1 lyMsg("FALLO R88"))
    if(axlDBCreateSymbol("R89" list(2500.000 865.000) nil 0.000) then n = n + 1 else bad = bad + 1 lyMsg("FALLO R89"))
    if(axlDBCreateSymbol("R9" list(1010.000 1765.000) nil 0.000) then n = n + 1 else bad = bad + 1 lyMsg("FALLO R9"))
    if(axlDBCreateSymbol("R90" list(2665.000 955.000) nil 0.000) then n = n + 1 else bad = bad + 1 lyMsg("FALLO R90"))
    if(axlDBCreateSymbol("R91" list(2750.000 1905.000) nil 0.000) then n = n + 1 else bad = bad + 1 lyMsg("FALLO R91"))
    if(axlDBCreateSymbol("R92" list(1840.000 975.000) nil 0.000) then n = n + 1 else bad = bad + 1 lyMsg("FALLO R92"))
    if(axlDBCreateSymbol("R93" list(2885.000 1205.000) nil 0.000) then n = n + 1 else bad = bad + 1 lyMsg("FALLO R93"))
    if(axlDBCreateSymbol("RB2" list(2349.089 394.866) t 90.000) then n = n + 1 else bad = bad + 1 lyMsg("FALLO RB2"))
    if(axlDBCreateSymbol("RB4" list(2389.089 394.866) t 90.000) then n = n + 1 else bad = bad + 1 lyMsg("FALLO RB4"))
    if(axlDBCreateSymbol("RD1" list(2395.000 785.000) nil 0.000) then n = n + 1 else bad = bad + 1 lyMsg("FALLO RD1"))
    if(axlDBCreateSymbol("RD10" list(1603.551 1557.700) nil 0.000) then n = n + 1 else bad = bad + 1 lyMsg("FALLO RD10"))
    if(axlDBCreateSymbol("RD11" list(1603.551 1782.700) nil 0.000) then n = n + 1 else bad = bad + 1 lyMsg("FALLO RD11"))
    if(axlDBCreateSymbol("RD12" list(1603.551 1647.700) nil 0.000) then n = n + 1 else bad = bad + 1 lyMsg("FALLO RD12"))
    if(axlDBCreateSymbol("RD13" list(1603.551 1692.700) nil 0.000) then n = n + 1 else bad = bad + 1 lyMsg("FALLO RD13"))
    if(axlDBCreateSymbol("RD14" list(2630.000 870.000) nil 0.000) then n = n + 1 else bad = bad + 1 lyMsg("FALLO RD14"))
    if(axlDBCreateSymbol("RD15" list(2780.000 990.000) nil 0.000) then n = n + 1 else bad = bad + 1 lyMsg("FALLO RD15"))
    if(axlDBCreateSymbol("RD17" list(2855.000 1090.000) nil 0.000) then n = n + 1 else bad = bad + 1 lyMsg("FALLO RD17"))
    if(axlDBCreateSymbol("RD18" list(2720.000 1995.000) nil 0.000) then n = n + 1 else bad = bad + 1 lyMsg("FALLO RD18"))
    if(axlDBCreateSymbol("RD19" list(2530.000 770.000) nil 0.000) then n = n + 1 else bad = bad + 1 lyMsg("FALLO RD19"))
    if(axlDBCreateSymbol("RD2" list(2685.000 2085.000) nil 0.000) then n = n + 1 else bad = bad + 1 lyMsg("FALLO RD2"))
    if(axlDBCreateSymbol("RD5" list(1715.000 960.000) nil 0.000) then n = n + 1 else bad = bad + 1 lyMsg("FALLO RD5"))
    if(axlDBCreateSymbol("RD7" list(1603.551 1827.700) nil 0.000) then n = n + 1 else bad = bad + 1 lyMsg("FALLO RD7"))
    if(axlDBCreateSymbol("RD8" list(1603.551 1737.700) nil 0.000) then n = n + 1 else bad = bad + 1 lyMsg("FALLO RD8"))
    if(axlDBCreateSymbol("RD81" list(2163.551 1842.700) t 270.000) then n = n + 1 else bad = bad + 1 lyMsg("FALLO RD81"))
    if(axlDBCreateSymbol("RD82" list(2163.551 1922.700) t 90.000) then n = n + 1 else bad = bad + 1 lyMsg("FALLO RD82"))
    if(axlDBCreateSymbol("RD85" list(2205.000 705.000) nil 0.000) then n = n + 1 else bad = bad + 1 lyMsg("FALLO RD85"))
    if(axlDBCreateSymbol("RD9" list(1603.551 1602.700) nil 0.000) then n = n + 1 else bad = bad + 1 lyMsg("FALLO RD9"))
    if(axlDBCreateSymbol("RP10" list(2330.000 700.000) nil 0.000) then n = n + 1 else bad = bad + 1 lyMsg("FALLO RP10"))
    if(axlDBCreateSymbol("RP11" list(2785.000 895.000) nil 0.000) then n = n + 1 else bad = bad + 1 lyMsg("FALLO RP11"))
    if(axlDBCreateSymbol("RP12" list(2660.000 775.000) nil 0.000) then n = n + 1 else bad = bad + 1 lyMsg("FALLO RP12"))
    if(axlDBCreateSymbol("RP176" list(2900.000 980.000) nil 0.000) then n = n + 1 else bad = bad + 1 lyMsg("FALLO RP176"))
    if(axlDBCreateSymbol("RP177" list(2970.000 1085.000) nil 0.000) then n = n + 1 else bad = bad + 1 lyMsg("FALLO RP177"))
    if(axlDBCreateSymbol("RP200" list(3020.000 1200.000) nil 0.000) then n = n + 1 else bad = bad + 1 lyMsg("FALLO RP200"))
    if(axlDBCreateSymbol("RP21" list(2010.000 510.000) nil 0.000) then n = n + 1 else bad = bad + 1 lyMsg("FALLO RP21"))
    if(axlDBCreateSymbol("RP23" list(1735.000 765.000) nil 0.000) then n = n + 1 else bad = bad + 1 lyMsg("FALLO RP23"))
    if(axlDBCreateSymbol("RP24" list(1735.000 635.000) nil 0.000) then n = n + 1 else bad = bad + 1 lyMsg("FALLO RP24"))
    if(axlDBCreateSymbol("RP25" list(2170.000 580.000) nil 0.000) then n = n + 1 else bad = bad + 1 lyMsg("FALLO RP25"))
    if(axlDBCreateSymbol("RP7" list(1720.000 885.000) nil 0.000) then n = n + 1 else bad = bad + 1 lyMsg("FALLO RP7"))
    if(axlDBCreateSymbol("RP75" list(2545.000 3425.000) nil 0.000) then n = n + 1 else bad = bad + 1 lyMsg("FALLO RP75"))
    if(axlDBCreateSymbol("RP76" list(2420.000 3350.000) nil 0.000) then n = n + 1 else bad = bad + 1 lyMsg("FALLO RP76"))
    if(axlDBCreateSymbol("RP8" list(2470.000 670.000) nil 0.000) then n = n + 1 else bad = bad + 1 lyMsg("FALLO RP8"))
    if(axlDBCreateSymbol("RP87" list(2743.551 1677.700) t 180.000) then n = n + 1 else bad = bad + 1 lyMsg("FALLO RP87"))
    if(axlDBCreateSymbol("RP9" list(1480.000 1640.000) nil 0.000) then n = n + 1 else bad = bad + 1 lyMsg("FALLO RP9"))
    if(axlDBCreateSymbol("TP1" list(1050.000 2545.000) nil 0.000) then n = n + 1 else bad = bad + 1 lyMsg("FALLO TP1"))
    if(axlDBCreateSymbol("TP10" list(2700.000 2300.000) nil 0.000) then n = n + 1 else bad = bad + 1 lyMsg("FALLO TP10"))
    if(axlDBCreateSymbol("TP11" list(2535.000 2625.000) nil 0.000) then n = n + 1 else bad = bad + 1 lyMsg("FALLO TP11"))
    if(axlDBCreateSymbol("TP12" list(2705.000 2425.000) nil 0.000) then n = n + 1 else bad = bad + 1 lyMsg("FALLO TP12"))
    if(axlDBCreateSymbol("TP13" list(2705.000 2175.000) nil 0.000) then n = n + 1 else bad = bad + 1 lyMsg("FALLO TP13"))
    if(axlDBCreateSymbol("TP14" list(2783.551 1542.700) t 0.000) then n = n + 1 else bad = bad + 1 lyMsg("FALLO TP14"))
    if(axlDBCreateSymbol("TP2" list(1005.000 2365.000) nil 0.000) then n = n + 1 else bad = bad + 1 lyMsg("FALLO TP2"))
    if(axlDBCreateSymbol("TP3" list(1005.000 2235.000) nil 0.000) then n = n + 1 else bad = bad + 1 lyMsg("FALLO TP3"))
    if(axlDBCreateSymbol("TP4" list(315.000 1630.000) nil 0.000) then n = n + 1 else bad = bad + 1 lyMsg("FALLO TP4"))
    if(axlDBCreateSymbol("TP5" list(1125.000 2705.000) nil 0.000) then n = n + 1 else bad = bad + 1 lyMsg("FALLO TP5"))
    if(axlDBCreateSymbol("TP6" list(1125.000 1895.000) nil 0.000) then n = n + 1 else bad = bad + 1 lyMsg("FALLO TP6"))
    if(axlDBCreateSymbol("TP7" list(230.000 950.000) nil 0.000) then n = n + 1 else bad = bad + 1 lyMsg("FALLO TP7"))
    if(axlDBCreateSymbol("TP8" list(1050.000 730.000) nil 0.000) then n = n + 1 else bad = bad + 1 lyMsg("FALLO TP8"))
    if(axlDBCreateSymbol("TP9" list(1265.000 1605.000) nil 0.000) then n = n + 1 else bad = bad + 1 lyMsg("FALLO TP9"))
    if(axlDBCreateSymbol("U1" list(1600.000 2300.000) nil 0.000) then n = n + 1 else bad = bad + 1 lyMsg("FALLO U1"))
    if(axlDBCreateSymbol("U10" list(1950.000 700.000) nil 0.000) then n = n + 1 else bad = bad + 1 lyMsg("FALLO U10"))
    if(axlDBCreateSymbol("U2" list(750.000 1250.000) nil 0.000) then n = n + 1 else bad = bad + 1 lyMsg("FALLO U2"))
    if(axlDBCreateSymbol("U23" list(2650.000 3200.000) nil 0.000) then n = n + 1 else bad = bad + 1 lyMsg("FALLO U23"))
    if(axlDBCreateSymbol("U27" list(2650.000 3650.000) nil 0.000) then n = n + 1 else bad = bad + 1 lyMsg("FALLO U27"))
    if(axlDBCreateSymbol("U3" list(2300.000 2300.000) nil 0.000) then n = n + 1 else bad = bad + 1 lyMsg("FALLO U3"))
    if(axlDBCreateSymbol("U4" list(1450.000 1300.000) nil 0.000) then n = n + 1 else bad = bad + 1 lyMsg("FALLO U4"))
    if(axlDBCreateSymbol("U5" list(1450.000 1050.000) nil 0.000) then n = n + 1 else bad = bad + 1 lyMsg("FALLO U5"))
    if(axlDBCreateSymbol("U6" list(2283.866 1449.866) nil 180.000) then n = n + 1 else bad = bad + 1 lyMsg("FALLO U6"))
    lyMsg(sprintf(nil "colocadas=%d fallos=%d" n bad))
    close(lyLog) lyLog = nil
    list(n bad)))
