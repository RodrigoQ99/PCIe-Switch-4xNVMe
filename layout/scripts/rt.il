;; rt.il -- PCB Router (Specctra) desde C:/rt (sin espacios en la ruta: el router falla con espacios)
procedure( rt_copy(src dst)
  let((i o l)
    i = infile(src) o = outfile(dst "w")
    while(gets(l i) fprintf(o "%s" l))
    close(i) close(o) t))
procedure( rt_do(passes)
  let((o)
    o = outfile("C:/rt/sw.do" "w")
    fprintf(o "do C:/rt/sw_rules.do\n")
    fprintf(o "bestsave on C:/rt/best.w\n")
    fprintf(o "protect all wires\n")
    fprintf(o "fanout 1 (pin_type power)\n")
    fprintf(o "route %d\n" passes)
    fprintf(o "clean 2\n")
    fprintf(o "route %d 16\n" passes + 25)
    fprintf(o "clean 2\n")
    fprintf(o "recorner diagonal\n")
    fprintf(o "write session C:/rt/sw.ses\n")
    fprintf(o "report status C:/rt/status.txt\n")
    fprintf(o "quit\n")
    close(o) t))
procedure( rt_prep()
  createDir("C:/rt")
  rt_copy("pcie_switch_4xnvme.dsn" "C:/rt/sw.dsn")
  rt_copy("pcie_switch_4xnvme_rules.do" "C:/rt/sw_rules.do")
  rt_do(25)
  printf("rt_prep ok %L\n" isFile("C:/rt/sw.dsn")))
procedure( rt_run()
  printf("router -> %L\n" system("C:/Cadence/OrCADX_25.1/tools/bin/specctra.exe C:/rt/sw.dsn -do C:/rt/sw.do -nog")))
procedure( rt_import()
  printf("import -> %L\n" axlRunBatchDBProgram("spif_batch" "spif_batch -i %s C:/rt/sw.ses" ?reloadDB t)))
