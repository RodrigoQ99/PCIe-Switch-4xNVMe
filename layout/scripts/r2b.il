;; r2b.il -- class-class: espaciado intra-clase de pares diferenciales = DIFF_SP (5 mil)
procedure( r2b_go()
  let((f)
    f = outfile("rules2.log" "w")
    foreach(nm list("DIFF_85OHM" "DIFF_85OHM_TX" "DIFF_85OHM_RX")
      fprintf(f "cc %s %L\n" nm axlCnsClassTableCreate(nm nm nil 'spacing "DIFF_SP")))
    fprintf(f "existentes %L\n" mapcar(lambda((x) list(x->objType x->name)) axlCnsClassTableFind('classClass)))
    fprintf(f "DRC=%L\n" axlDRCUpdate(nil))
    fprintf(f "save %L\n" axlSaveDesign(?noConfirm t))
    close(f)
    l2_dump("place15.txt") t))
