;; fp_gen.il  --  generado por gen_fp.py (no editar a mano)
;; Uso (Allegro, con fp_blank.dra abierto en 03 Layout\lib):
;;   skill load("../scripts/fp_gen.il")
;;   skill fp_all()
fpLogPort = nil
fpErrs = 0
procedure( fpLog(msg)
  when(fpLogPort fprintf(fpLogPort "%s\n" msg) drain(fpLogPort))
  printf("%s\n" msg))
procedure( fpErr(msg) fpErrs = fpErrs + 1 fpLog(strcat("  ERROR: " msg)))
procedure( fpTxt(tb) make_axlTextOrientation(?textBlock tb ?rotation 0.0 ?mirrored nil ?justify "center"))

procedure( fpBegin(name)
  let((u)
    fpErrs = 0
    fpLog(strcat("== " name))
    unless(axlOpenDesign(?design "fp_blank.dra" ?mode "wf") fpErr("no abre fp_blank.dra"))
    axlSetSymbolType("package")
    u = axlDBGetDesignUnits()
    when(listp(u) u = car(u))
    when(stringp(u) u = lowerCase(u))
    unless(u == "millimeters"
      unless(axlDBChangeDesignUnits("millimeters" 4)
        unless(axlDBChangeDesignUnits("millimeters" nil) fpErr("no cambia unidades a mm"))))
    fpLog(sprintf(nil "  unidades: %L" axlDBGetDesignUnits()))
    unless(axlDBChangeDesignExtents(list(list(-120.0 -120.0) list(120.0 120.0))) fpErr("extents"))))

procedure( fpSMD(name fig w h pw ph masked)
  let((pads r)
    pads = list(make_axlPadStackPad(?layer "TOP" ?type 'REGULAR ?figure fig ?figureSize list(w h)))
    when(masked
      pads = cons(make_axlPadStackPad(?layer "SOLDERMASK_TOP" ?type 'REGULAR ?figure fig
                    ?figureSize list(w+2*0.05 h+2*0.05)) pads))
    when(pw > 0.0
      pads = cons(make_axlPadStackPad(?layer "PASTEMASK_TOP" ?type 'REGULAR ?figure fig
                    ?figureSize list(pw ph)) pads))
    r = axlDBCreatePadStack(name nil pads t)
    unless(r fpErr(strcat("padstack " name)))
    r))

procedure( fpNPTH(name d)
  let((dr pads r)
    dr = make_axlPadStackDrill(?holeType 'CIRCLE_DRILL ?drillDiameter d ?plating 'NON_PLATED
                               ?figure 'CIRCLE ?figureSize list(d d) ?drillChar "N")
    pads = list(make_axlPadStackPad(?layer "SOLDERMASK_TOP" ?type 'REGULAR ?figure 'CIRCLE ?figureSize list(d+0.2 d+0.2))
                make_axlPadStackPad(?layer "SOLDERMASK_BOTTOM" ?type 'REGULAR ?figure 'CIRCLE ?figureSize list(d+0.2 d+0.2)))
    r = axlDBCreatePadStack(name dr pads t)
    unless(r fpErr(strcat("padstack " name)))
    r))

procedure( fpPin(ps x y num rot)
  let((pt r)
    pt = if(num make_axlPinText(?number num ?offset list(0.0 0.0) ?text fpTxt(1)) nil)
    r = axlDBCreatePin(ps list(x y) pt rot)
    unless(r fpErr(sprintf(nil "pin %L en %L %L" num x y)))
    r))

procedure( fpPoly(layer pts)
  let((p)
    p = axlPathStart(pts 0.0)
    unless(p && axlDBCreateShape(p t layer) fpErr(strcat("shape " layer)))))

procedure( fpLine(layer pts w)
  unless(axlDBCreateLine(pts w layer) fpErr(strcat("linea " layer))))

procedure( fpEnd(name ref x1 y1 x2 y2 pss)
  let((s c)
    unless(axlDBCreateRectangle(list(list(x1 y1) list(x2 y2)) t "PACKAGE GEOMETRY/PLACE_BOUND_TOP")
      fpErr("place bound"))
    unless(axlDBCreateText(ref list(0.0 0.0) fpTxt(2) "REF DES/ASSEMBLY_TOP") fpErr("refdes asm"))
    s = axlSaveDesign(?design name ?noConfirm t)
    c = axlCompileSymbol(?symbol name ?silent t ?silentOnOverwrite t)
    foreach(p pss unless(axlPadstackToDisk(p) fpErr(strcat("pad a disco " p))))
    fpLog(sprintf(nil "  save=%L psm=%L errores=%d" s c fpErrs))))

procedure( fp_0()
  fpBegin("so14-6-1_27")
  fpSMD("smd_r1950x600" 'RECTANGLE 1.95 0.6 1.95 0.6 t)
  fpPin("smd_r1950x600" -2.475 3.81 "1" 0.0)
  fpPin("smd_r1950x600" -2.475 2.54 "2" 0.0)
  fpPin("smd_r1950x600" -2.475 1.27 "3" 0.0)
  fpPin("smd_r1950x600" -2.475 0.0 "4" 0.0)
  fpPin("smd_r1950x600" -2.475 -1.27 "5" 0.0)
  fpPin("smd_r1950x600" -2.475 -2.54 "6" 0.0)
  fpPin("smd_r1950x600" -2.475 -3.81 "7" 0.0)
  fpPin("smd_r1950x600" 2.475 -3.81 "8" 0.0)
  fpPin("smd_r1950x600" 2.475 -2.54 "9" 0.0)
  fpPin("smd_r1950x600" 2.475 -1.27 "10" 0.0)
  fpPin("smd_r1950x600" 2.475 0.0 "11" 0.0)
  fpPin("smd_r1950x600" 2.475 1.27 "12" 0.0)
  fpPin("smd_r1950x600" 2.475 2.54 "13" 0.0)
  fpPin("smd_r1950x600" 2.475 3.81 "14" 0.0)
  fpLine("PACKAGE GEOMETRY/SILKSCREEN_TOP" list(list(0.0 -4.435) list(1.95 -4.435)) 0.12)
  fpLine("PACKAGE GEOMETRY/SILKSCREEN_TOP" list(list(0.0 -4.435) list(-1.95 -4.435)) 0.12)
  fpLine("PACKAGE GEOMETRY/SILKSCREEN_TOP" list(list(0.0 4.435) list(1.95 4.435)) 0.12)
  fpLine("PACKAGE GEOMETRY/SILKSCREEN_TOP" list(list(0.0 4.435) list(-3.45 4.435)) 0.12)
  fpLine("PACKAGE GEOMETRY/ASSEMBLY_TOP" list(list(-0.975 4.325) list(1.95 4.325)) 0.0)
  fpLine("PACKAGE GEOMETRY/ASSEMBLY_TOP" list(list(1.95 4.325) list(1.95 -4.325)) 0.0)
  fpLine("PACKAGE GEOMETRY/ASSEMBLY_TOP" list(list(1.95 -4.325) list(-1.95 -4.325)) 0.0)
  fpLine("PACKAGE GEOMETRY/ASSEMBLY_TOP" list(list(-1.95 -4.325) list(-1.95 3.35)) 0.0)
  fpLine("PACKAGE GEOMETRY/ASSEMBLY_TOP" list(list(-1.95 3.35) list(-0.975 4.325)) 0.0)
  axlDBCreateText("U*" list(0.0 5.28) fpTxt(2) "REF DES/SILKSCREEN_TOP")
  fpEnd("so14-6-1_27" "U*" -3.7 -4.58 3.7 4.58 list("smd_r1950x600")))

procedure( fp_1()
  fpBegin("tssop20-6_5-_65")
  fpSMD("smd_r1475x400" 'RECTANGLE 1.475 0.4 1.475 0.4 t)
  fpPin("smd_r1475x400" -2.8625 2.925 "1" 0.0)
  fpPin("smd_r1475x400" -2.8625 2.275 "2" 0.0)
  fpPin("smd_r1475x400" -2.8625 1.625 "3" 0.0)
  fpPin("smd_r1475x400" -2.8625 0.975 "4" 0.0)
  fpPin("smd_r1475x400" -2.8625 0.325 "5" 0.0)
  fpPin("smd_r1475x400" -2.8625 -0.325 "6" 0.0)
  fpPin("smd_r1475x400" -2.8625 -0.975 "7" 0.0)
  fpPin("smd_r1475x400" -2.8625 -1.625 "8" 0.0)
  fpPin("smd_r1475x400" -2.8625 -2.275 "9" 0.0)
  fpPin("smd_r1475x400" -2.8625 -2.925 "10" 0.0)
  fpPin("smd_r1475x400" 2.8625 -2.925 "11" 0.0)
  fpPin("smd_r1475x400" 2.8625 -2.275 "12" 0.0)
  fpPin("smd_r1475x400" 2.8625 -1.625 "13" 0.0)
  fpPin("smd_r1475x400" 2.8625 -0.975 "14" 0.0)
  fpPin("smd_r1475x400" 2.8625 -0.325 "15" 0.0)
  fpPin("smd_r1475x400" 2.8625 0.325 "16" 0.0)
  fpPin("smd_r1475x400" 2.8625 0.975 "17" 0.0)
  fpPin("smd_r1475x400" 2.8625 1.625 "18" 0.0)
  fpPin("smd_r1475x400" 2.8625 2.275 "19" 0.0)
  fpPin("smd_r1475x400" 2.8625 2.925 "20" 0.0)
  fpLine("PACKAGE GEOMETRY/SILKSCREEN_TOP" list(list(0.0 -3.385) list(2.2 -3.385)) 0.12)
  fpLine("PACKAGE GEOMETRY/SILKSCREEN_TOP" list(list(0.0 -3.385) list(-2.2 -3.385)) 0.12)
  fpLine("PACKAGE GEOMETRY/SILKSCREEN_TOP" list(list(0.0 3.385) list(2.2 3.385)) 0.12)
  fpLine("PACKAGE GEOMETRY/SILKSCREEN_TOP" list(list(0.0 3.385) list(-3.6 3.385)) 0.12)
  fpLine("PACKAGE GEOMETRY/ASSEMBLY_TOP" list(list(-1.2 3.25) list(2.2 3.25)) 0.0)
  fpLine("PACKAGE GEOMETRY/ASSEMBLY_TOP" list(list(2.2 3.25) list(2.2 -3.25)) 0.0)
  fpLine("PACKAGE GEOMETRY/ASSEMBLY_TOP" list(list(2.2 -3.25) list(-2.2 -3.25)) 0.0)
  fpLine("PACKAGE GEOMETRY/ASSEMBLY_TOP" list(list(-2.2 -3.25) list(-2.2 2.25)) 0.0)
  fpLine("PACKAGE GEOMETRY/ASSEMBLY_TOP" list(list(-2.2 2.25) list(-1.2 3.25)) 0.0)
  axlDBCreateText("U*" list(0.0 4.2) fpTxt(2) "REF DES/SILKSCREEN_TOP")
  fpEnd("tssop20-6_5-_65" "U*" -3.85 -3.5 3.85 3.5 list("smd_r1475x400")))

procedure( fp_2()
  fpBegin("l1812")
  fpSMD("smd_r1125x3400" 'RECTANGLE 1.125 3.4 1.125 3.4 t)
  fpPin("smd_r1125x3400" -2.1375 0.0 "1" 0.0)
  fpPin("smd_r1125x3400" 2.1375 0.0 "2" 0.0)
  fpLine("PACKAGE GEOMETRY/ASSEMBLY_TOP" list(list(-2.25 -1.6) list(-2.25 1.6)) 0.0)
  fpLine("PACKAGE GEOMETRY/ASSEMBLY_TOP" list(list(-2.25 1.6) list(2.25 1.6)) 0.0)
  fpLine("PACKAGE GEOMETRY/ASSEMBLY_TOP" list(list(2.25 1.6) list(2.25 -1.6)) 0.0)
  fpLine("PACKAGE GEOMETRY/ASSEMBLY_TOP" list(list(2.25 -1.6) list(-2.25 -1.6)) 0.0)
  fpLine("PACKAGE GEOMETRY/SILKSCREEN_TOP" list(list(-1.3863 1.71) list(1.3863 1.71)) 0.12)
  fpLine("PACKAGE GEOMETRY/SILKSCREEN_TOP" list(list(-1.3863 -1.71) list(1.3863 -1.71)) 0.12)
  axlDBCreateText("U*" list(0.0 2.65) fpTxt(2) "REF DES/SILKSCREEN_TOP")
  fpEnd("l1812" "U*" -2.95 -1.95 2.95 1.95 list("smd_r1125x3400")))

procedure( fp_3()
  fpBegin("7_3x4_3x2_8")
  fpSMD("smd_r2075x2550" 'RECTANGLE 2.075 2.55 2.075 2.55 t)
  fpPin("smd_r2075x2550" -3.1125 0.0 "1" 0.0)
  fpPin("smd_r2075x2550" 3.1125 0.0 "2" 0.0)
  fpLine("PACKAGE GEOMETRY/ASSEMBLY_TOP" list(list(3.65 2.15) list(-2.65 2.15)) 0.0)
  fpLine("PACKAGE GEOMETRY/ASSEMBLY_TOP" list(list(-2.65 2.15) list(-3.65 1.15)) 0.0)
  fpLine("PACKAGE GEOMETRY/ASSEMBLY_TOP" list(list(-3.65 1.15) list(-3.65 -2.15)) 0.0)
  fpLine("PACKAGE GEOMETRY/ASSEMBLY_TOP" list(list(-3.65 -2.15) list(3.65 -2.15)) 0.0)
  fpLine("PACKAGE GEOMETRY/ASSEMBLY_TOP" list(list(3.65 -2.15) list(3.65 2.15)) 0.0)
  fpLine("PACKAGE GEOMETRY/SILKSCREEN_TOP" list(list(3.65 2.26) list(-4.41 2.26)) 0.12)
  fpLine("PACKAGE GEOMETRY/SILKSCREEN_TOP" list(list(-4.41 2.26) list(-4.41 -2.26)) 0.12)
  fpLine("PACKAGE GEOMETRY/SILKSCREEN_TOP" list(list(-4.41 -2.26) list(3.65 -2.26)) 0.12)
  axlDBCreateText("U*" list(0.0 3.1) fpTxt(2) "REF DES/SILKSCREEN_TOP")
  fpEnd("7_3x4_3x2_8" "U*" -4.4 -2.4 4.4 2.4 list("smd_r2075x2550")))

procedure( fp_4()
  fpBegin("dfn8-0303-_65")
  fpSMD("smd_r650x300" 'RECTANGLE 0.65 0.3 0.65 0.3 t)
  fpSMD("smd_r1600x2350p80" 'RECTANGLE 1.6 2.35 1.28 1.88 t)
  fpPin("smd_r650x300" -1.375 0.975 "1" 0.0)
  fpPin("smd_r650x300" 1.375 0.975 "8" 0.0)
  fpPin("smd_r650x300" -1.375 0.325 "2" 0.0)
  fpPin("smd_r650x300" 1.375 0.325 "7" 0.0)
  fpPin("smd_r650x300" -1.375 -0.325 "3" 0.0)
  fpPin("smd_r650x300" 1.375 -0.325 "6" 0.0)
  fpPin("smd_r650x300" -1.375 -0.975 "4" 0.0)
  fpPin("smd_r650x300" 1.375 -0.975 "5" 0.0)
  fpPin("smd_r1600x2350p80" 0.0 0.0 "9" 0.0)
  fpLine("PACKAGE GEOMETRY/ASSEMBLY_TOP" list(list(-1.5 1.5) list(1.5 1.5) list(1.5 -1.5) list(-1.5 -1.5) list(-1.5 1.5)) 0.0)
  fpLine("PACKAGE GEOMETRY/SILKSCREEN_TOP" list(list(-0.9 1.62) list(0.9 1.62)) 0.12)
  fpLine("PACKAGE GEOMETRY/SILKSCREEN_TOP" list(list(-0.9 -1.62) list(0.9 -1.62)) 0.12)
  fpLine("PACKAGE GEOMETRY/SILKSCREEN_TOP" list(list(-2.05 1.55) list(-2.05 1.25)) 0.12)
  axlDBCreateText("U*" list(0.0 2.3) fpTxt(2) "REF DES/SILKSCREEN_TOP")
  fpEnd("dfn8-0303-_65" "U*" -2.0 -1.75 2.0 1.75 list("smd_r650x300" "smd_r1600x2350p80")))

procedure( fp_5()
  fpBegin("455580003")
  fpNPTH("npth_3200" 3.2)
  fpPin("pad100cir70ds105" 0.0 0.0 "1" 0.0)
  fpPin("pad100cir70ds105" 4.2 0.0 "2" 0.0)
  fpPin("pad100cir70ds105" 8.4 0.0 "3" 0.0)
  fpPin("pad100cir70ds105" 0.0 -5.5 "4" 0.0)
  fpPin("pad100cir70ds105" 4.2 -5.5 "5" 0.0)
  fpPin("pad100cir70ds105" 8.4 -5.5 "6" 0.0)
  fpPin("npth_3200" -4.5 4.2 nil 0.0)
  fpPin("npth_3200" 12.9 4.2 nil 0.0)
  fpLine("PACKAGE GEOMETRY/ASSEMBLY_TOP" list(list(-2.7 13.9) list(-2.7 1.1)) 0.0)
  fpLine("PACKAGE GEOMETRY/ASSEMBLY_TOP" list(list(-2.7 1.1) list(11.1 1.1)) 0.0)
  fpLine("PACKAGE GEOMETRY/ASSEMBLY_TOP" list(list(11.1 1.1) list(11.1 13.9)) 0.0)
  fpLine("PACKAGE GEOMETRY/ASSEMBLY_TOP" list(list(11.1 13.9) list(-2.7 13.9)) 0.0)
  fpLine("PACKAGE GEOMETRY/ASSEMBLY_TOP" list(list(-2.7 7.3) list(-7.7 7.3)) 0.0)
  fpLine("PACKAGE GEOMETRY/ASSEMBLY_TOP" list(list(-7.7 7.3) list(-7.7 1.1)) 0.0)
  fpLine("PACKAGE GEOMETRY/ASSEMBLY_TOP" list(list(-7.7 1.1) list(-2.7 1.1)) 0.0)
  fpLine("PACKAGE GEOMETRY/ASSEMBLY_TOP" list(list(11.1 7.3) list(16.1 7.3)) 0.0)
  fpLine("PACKAGE GEOMETRY/ASSEMBLY_TOP" list(list(16.1 7.3) list(16.1 1.1)) 0.0)
  fpLine("PACKAGE GEOMETRY/ASSEMBLY_TOP" list(list(16.1 1.1) list(11.1 1.1)) 0.0)
  fpLine("PACKAGE GEOMETRY/SILKSCREEN_TOP" list(list(4.2 14.01) list(-2.81 14.01)) 0.12)
  fpLine("PACKAGE GEOMETRY/SILKSCREEN_TOP" list(list(-2.81 14.01) list(-2.81 7.41)) 0.12)
  fpLine("PACKAGE GEOMETRY/SILKSCREEN_TOP" list(list(-2.81 7.41) list(-7.81 7.41)) 0.12)
  fpLine("PACKAGE GEOMETRY/SILKSCREEN_TOP" list(list(-7.81 7.41) list(-7.81 0.99)) 0.12)
  fpLine("PACKAGE GEOMETRY/SILKSCREEN_TOP" list(list(-7.81 0.99) list(-2.0 0.99)) 0.12)
  fpLine("PACKAGE GEOMETRY/SILKSCREEN_TOP" list(list(4.2 14.01) list(11.21 14.01)) 0.12)
  fpLine("PACKAGE GEOMETRY/SILKSCREEN_TOP" list(list(11.21 14.01) list(11.21 7.41)) 0.12)
  fpLine("PACKAGE GEOMETRY/SILKSCREEN_TOP" list(list(11.21 7.41) list(16.21 7.41)) 0.12)
  fpLine("PACKAGE GEOMETRY/SILKSCREEN_TOP" list(list(16.21 7.41) list(16.21 0.99)) 0.12)
  fpLine("PACKAGE GEOMETRY/SILKSCREEN_TOP" list(list(16.21 0.99) list(10.4 0.99)) 0.12)
  fpLine("PACKAGE GEOMETRY/SILKSCREEN_TOP" list(list(-0.3 -2.11) list(-0.3 -3.39)) 0.12)
  fpLine("PACKAGE GEOMETRY/SILKSCREEN_TOP" list(list(0.3 -2.11) list(0.3 -3.39)) 0.12)
  fpLine("PACKAGE GEOMETRY/SILKSCREEN_TOP" list(list(3.9 -2.11) list(3.9 -3.39)) 0.12)
  fpLine("PACKAGE GEOMETRY/SILKSCREEN_TOP" list(list(4.5 -2.11) list(4.5 -3.39)) 0.12)
  fpLine("PACKAGE GEOMETRY/SILKSCREEN_TOP" list(list(8.1 -2.11) list(8.1 -3.39)) 0.12)
  fpLine("PACKAGE GEOMETRY/SILKSCREEN_TOP" list(list(8.7 -2.11) list(8.7 -3.39)) 0.12)
  fpLine("PACKAGE GEOMETRY/SILKSCREEN_TOP" list(list(1.61 1.0) list(2.59 1.0)) 0.12)
  fpLine("PACKAGE GEOMETRY/SILKSCREEN_TOP" list(list(5.81 1.0) list(6.79 1.0)) 0.12)
  fpLine("PACKAGE GEOMETRY/SILKSCREEN_TOP" list(list(-2.0 0.0) list(-2.6 -0.3)) 0.12)
  fpLine("PACKAGE GEOMETRY/SILKSCREEN_TOP" list(list(-2.6 -0.3) list(-2.6 0.3)) 0.12)
  fpLine("PACKAGE GEOMETRY/SILKSCREEN_TOP" list(list(-2.6 0.3) list(-2.0 0.0)) 0.12)
  fpLine("PACKAGE GEOMETRY/ASSEMBLY_TOP" list(list(-1.0 1.1) list(0.0 2.5142)) 0.0)
  fpLine("PACKAGE GEOMETRY/ASSEMBLY_TOP" list(list(0.0 2.5142) list(1.0 1.1)) 0.0)
  axlDBCreateText("U*" list(4.2 15.1) fpTxt(2) "REF DES/SILKSCREEN_TOP")
  fpEnd("455580003" "U*" -8.2 -7.85 16.6 14.4 list("npth_3200")))

procedure( fp_6()
  fpBegin("b3qfn-42")
  fpSMD("smd_s1650x1650" 'SQUARE 1.65 1.65 1.65 1.65 t)
  fpSMD("smd_r950x500" 'RECTANGLE 0.95 0.5 0.95 0.5 t)
  fpSMD("smd_r3290x1400p00" 'RECTANGLE 3.29 1.4 0.0 0.0 t)
  fpPin("smd_s1650x1650" -4.575 4.575 "1" 0.0)
  fpPin("smd_r950x500" -4.925 3.2 "2" 0.0)
  fpPin("smd_r950x500" -4.925 2.4 "3" 0.0)
  fpPin("smd_r950x500" -4.925 1.6 "4" 0.0)
  fpPin("smd_r950x500" -4.925 0.8 "5" 0.0)
  fpPin("smd_r950x500" -4.925 0.0 "6" 0.0)
  fpPin("smd_r950x500" -4.925 -0.8 "7" 0.0)
  fpPin("smd_r950x500" -4.925 -1.6 "8" 0.0)
  fpPin("smd_r950x500" -4.925 -2.4 "9" 0.0)
  fpPin("smd_r950x500" -4.925 -3.2 "10" 0.0)
  fpPin("smd_s1650x1650" -4.575 -4.575 "11" 0.0)
  fpPin("smd_r950x500" -3.2 -4.925 "12" 90.0)
  fpPin("smd_r950x500" -2.4 -4.925 "13" 90.0)
  fpPin("smd_r950x500" -1.6 -4.925 "14" 90.0)
  fpPin("smd_r950x500" -0.8 -4.925 "15" 90.0)
  fpPin("smd_r950x500" 0.0 -4.925 "16" 90.0)
  fpPin("smd_r950x500" 0.8 -4.925 "17" 90.0)
  fpPin("smd_r950x500" 1.6 -4.925 "18" 90.0)
  fpPin("smd_r950x500" 2.4 -4.925 "19" 90.0)
  fpPin("smd_r950x500" 3.2 -4.925 "20" 90.0)
  fpPin("smd_s1650x1650" 4.575 -4.575 "21" 0.0)
  fpPin("smd_r950x500" 4.925 -3.2 "22" 0.0)
  fpPin("smd_r950x500" 4.925 -2.4 "23" 0.0)
  fpPin("smd_r950x500" 4.925 -1.6 "24" 0.0)
  fpPin("smd_r950x500" 4.925 -0.8 "25" 0.0)
  fpPin("smd_r950x500" 4.925 0.0 "26" 0.0)
  fpPin("smd_r950x500" 4.925 0.8 "27" 0.0)
  fpPin("smd_r950x500" 4.925 1.6 "28" 0.0)
  fpPin("smd_r950x500" 4.925 2.4 "29" 0.0)
  fpPin("smd_r950x500" 4.925 3.2 "30" 0.0)
  fpPin("smd_s1650x1650" 4.575 4.575 "31" 0.0)
  fpPin("smd_r950x500" 3.2 4.925 "32" 90.0)
  fpPin("smd_r950x500" 2.4 4.925 "33" 90.0)
  fpPin("smd_r950x500" 1.6 4.925 "34" 90.0)
  fpPin("smd_r950x500" 0.8 4.925 "35" 90.0)
  fpPin("smd_r950x500" 0.0 4.925 "36" 90.0)
  fpPin("smd_r950x500" -0.8 4.925 "37" 90.0)
  fpPin("smd_r950x500" -1.6 4.925 "38" 90.0)
  fpPin("smd_r950x500" -2.4 4.925 "39" 90.0)
  fpPin("smd_r950x500" -3.2 4.925 "40" 90.0)
  fpPin("smd_r3290x1400p00" 0.0 3.55 "41" 0.0)
  fpPin("smd_r3290x1400p00" 0.0 -3.55 "42" 0.0)
  fpLine("PACKAGE GEOMETRY/ASSEMBLY_TOP" list(list(-5.075 -5.075) list(5.075 -5.075)) 0.0)
  fpLine("PACKAGE GEOMETRY/ASSEMBLY_TOP" list(list(-5.075 5.075) list(5.075 5.075)) 0.0)
  fpLine("PACKAGE GEOMETRY/ASSEMBLY_TOP" list(list(5.075 -5.075) list(5.075 5.075)) 0.0)
  fpLine("PACKAGE GEOMETRY/ASSEMBLY_TOP" list(list(-5.075 -5.075) list(-5.075 5.075)) 0.0)
  fpLine("PACKAGE GEOMETRY/SILKSCREEN_TOP" list(list(-5.65 -5.65) list(-4.875 -5.65)) 0.12)
  fpLine("PACKAGE GEOMETRY/SILKSCREEN_TOP" list(list(-5.65 -5.65) list(-5.65 -4.875)) 0.12)
  fpLine("PACKAGE GEOMETRY/SILKSCREEN_TOP" list(list(5.65 -5.65) list(5.65 -4.875)) 0.12)
  fpLine("PACKAGE GEOMETRY/SILKSCREEN_TOP" list(list(4.875 -5.65) list(5.65 -5.65)) 0.12)
  fpLine("PACKAGE GEOMETRY/SILKSCREEN_TOP" list(list(5.65 4.875) list(5.65 5.65)) 0.12)
  fpLine("PACKAGE GEOMETRY/SILKSCREEN_TOP" list(list(4.875 5.65) list(5.65 5.65)) 0.12)
  fpLine("PACKAGE GEOMETRY/SILKSCREEN_TOP" list(list(-5.65 5.65) list(-3.9 5.65)) 0.12)
  fpLine("PACKAGE GEOMETRY/SILKSCREEN_TOP" list(list(-5.65 4.0) list(-5.65 5.65)) 0.12)
  fpPoly("PACKAGE GEOMETRY/PASTEMASK_TOP" list(list(0.15 -3.4) list(1.62 -3.4) list(1.62 -2.87) list(0.15 -2.87) list(0.15 -3.4)))
  fpPoly("PACKAGE GEOMETRY/PASTEMASK_TOP" list(list(0.15 -4.23) list(1.62 -4.23) list(1.62 -3.7) list(0.15 -3.7) list(0.15 -4.23)))
  fpPoly("PACKAGE GEOMETRY/PASTEMASK_TOP" list(list(-1.62 -4.23) list(-0.15 -4.23) list(-0.15 -3.7) list(-1.62 -3.7) list(-1.62 -4.23)))
  fpPoly("PACKAGE GEOMETRY/PASTEMASK_TOP" list(list(-1.62 -3.4) list(-0.15 -3.4) list(-0.15 -2.87) list(-1.62 -2.87) list(-1.62 -3.4)))
  fpPoly("PACKAGE GEOMETRY/PASTEMASK_TOP" list(list(-0.2375 -2.5175) list(0.2375 -2.5175) list(0.2375 -1.2875) list(-0.2375 -1.2875) list(-0.2375 -2.5175)))
  fpPoly("PACKAGE GEOMETRY/PASTEMASK_TOP" list(list(-0.2375 -0.9875) list(0.2375 -0.9875) list(0.2375 0.2425) list(-0.2375 0.2425) list(-0.2375 -0.9875)))
  fpPoly("PACKAGE GEOMETRY/PASTEMASK_TOP" list(list(-0.2375 0.5425) list(0.2375 0.5425) list(0.2375 1.7725) list(-0.2375 1.7725) list(-0.2375 0.5425)))
  fpPoly("PACKAGE GEOMETRY/PASTEMASK_TOP" list(list(0.15 3.7) list(1.62 3.7) list(1.62 4.23) list(0.15 4.23) list(0.15 3.7)))
  fpPoly("PACKAGE GEOMETRY/PASTEMASK_TOP" list(list(0.15 2.87) list(1.62 2.87) list(1.62 3.4) list(0.15 3.4) list(0.15 2.87)))
  fpPoly("PACKAGE GEOMETRY/PASTEMASK_TOP" list(list(-1.62 2.87) list(-0.15 2.87) list(-0.15 3.4) list(-1.62 3.4) list(-1.62 2.87)))
  fpPoly("PACKAGE GEOMETRY/PASTEMASK_TOP" list(list(-1.62 3.7) list(-0.15 3.7) list(-0.15 4.23) list(-1.62 4.23) list(-1.62 3.7)))
  fpPoly("ETCH/TOP" list(list(-1.645 -4.25) list(-1.645 -2.25) list(-0.8625 -2.25) list(-0.8625 1.8) list(0.8625 1.8) list(0.8625 -2.25) list(1.645 -2.25) list(1.645 -4.25) list(-1.645 -4.25)))
  fpPoly("PACKAGE GEOMETRY/SOLDERMASK_TOP" list(list(1.645 -4.25) list(-1.645 -4.25) list(-1.645 -2.85) list(-0.2625 -2.85) list(-0.2625 1.8) list(0.2625 1.8) list(0.2625 -2.85) list(1.645 -2.85) list(1.645 -4.25)))
  axlDBCreateText("U*" list(0.0 0.0) fpTxt(2) "REF DES/SILKSCREEN_TOP")
  fpEnd("b3qfn-42" "U*" -5.65 -5.65 5.65 5.65 list("smd_s1650x1650" "smd_r950x500" "smd_r3290x1400p00")))

procedure( fp_7()
  fpBegin("qfn72-16r15x15r15-_8")
  fpSMD("smd_s1000x1000p00" 'SQUARE 1.0 1.0 0.0 0.0 t)
  fpSMD("smd_r950x500" 'RECTANGLE 0.95 0.5 0.95 0.5 t)
  fpSMD("smd_r2250x1735" 'RECTANGLE 2.25 1.735 2.25 1.735 t)
  fpSMD("smd_r2950x800" 'RECTANGLE 2.95 0.8 2.95 0.8 t)
  fpSMD("smd_r2300x1330p00" 'RECTANGLE 2.3 1.33 0.0 0.0 t)
  fpSMD("smd_r2300x2250p00" 'RECTANGLE 2.3 2.25 0.0 0.0 t)
  fpSMD("smd_r4720x2800" 'RECTANGLE 4.72 2.8 4.72 2.8 t)
  fpSMD("smd_r4720x2250" 'RECTANGLE 4.72 2.25 4.72 2.25 t)
  fpPin("smd_s1000x1000p00" -6.865 7.7 "1" 90.0)
  fpPin("smd_r950x500" -7.405 5.6 "2" 0.0)
  fpPin("smd_r950x500" -7.405 4.8 "3" 0.0)
  fpPin("smd_r950x500" -7.405 4.0 "4" 0.0)
  fpPin("smd_r950x500" -7.405 3.2 "5" 0.0)
  fpPin("smd_r950x500" -7.405 2.4 "6" 0.0)
  fpPin("smd_r950x500" -7.405 1.6 "7" 0.0)
  fpPin("smd_r950x500" -7.405 0.8 "8" 0.0)
  fpPin("smd_r950x500" -7.405 -0.0 "9" 0.0)
  fpPin("smd_r950x500" -7.405 -0.8 "10" 0.0)
  fpPin("smd_r950x500" -7.405 -1.6 "11" 0.0)
  fpPin("smd_r950x500" -7.405 -2.4 "12" 0.0)
  fpPin("smd_r950x500" -7.405 -3.2 "13" 0.0)
  fpPin("smd_r950x500" -7.405 -4.0 "14" 0.0)
  fpPin("smd_r950x500" -7.405 -4.8 "15" 0.0)
  fpPin("smd_r950x500" -7.405 -5.6 "16" 0.0)
  fpPin("smd_r2250x1735" -7.015 -7.275 "17" 90.0)
  fpPin("smd_r950x500" -5.6025 -7.925 "18" 90.0)
  fpPin("smd_r950x500" -4.8025 -7.925 "19" 90.0)
  fpPin("smd_r950x500" -4.0025 -7.925 "20" 90.0)
  fpPin("smd_r950x500" -3.2025 -7.925 "21" 90.0)
  fpPin("smd_r950x500" -2.4025 -7.925 "22" 90.0)
  fpPin("smd_r950x500" -1.6025 -7.925 "23" 90.0)
  fpPin("smd_r950x500" -0.8025 -7.925 "24" 90.0)
  fpPin("smd_r950x500" -0.0025 -7.925 "25" 90.0)
  fpPin("smd_r950x500" 0.7975 -7.925 "26" 90.0)
  fpPin("smd_r950x500" 1.5975 -7.925 "27" 90.0)
  fpPin("smd_r950x500" 2.3975 -7.925 "28" 90.0)
  fpPin("smd_r950x500" 3.1975 -7.925 "29" 90.0)
  fpPin("smd_r950x500" 3.9975 -7.925 "30" 90.0)
  fpPin("smd_r950x500" 4.7975 -7.925 "31" 90.0)
  fpPin("smd_r950x500" 5.5975 -7.925 "32" 90.0)
  fpPin("smd_r2250x1735" 7.015 -7.275 "33" 90.0)
  fpPin("smd_r950x500" 7.405 -5.6 "34" 0.0)
  fpPin("smd_r950x500" 7.405 -4.8 "35" 0.0)
  fpPin("smd_r950x500" 7.405 -4.0 "36" 0.0)
  fpPin("smd_r950x500" 7.405 -3.2 "37" 0.0)
  fpPin("smd_r950x500" 7.405 -2.4 "38" 0.0)
  fpPin("smd_r950x500" 7.405 -1.6 "39" 0.0)
  fpPin("smd_r950x500" 7.405 -0.8 "40" 0.0)
  fpPin("smd_r950x500" 7.405 -0.0 "41" 0.0)
  fpPin("smd_r950x500" 7.405 0.8 "42" 0.0)
  fpPin("smd_r950x500" 7.405 1.6 "43" 0.0)
  fpPin("smd_r950x500" 7.405 2.4 "44" 0.0)
  fpPin("smd_r950x500" 7.405 3.2 "45" 0.0)
  fpPin("smd_r950x500" 7.405 4.0 "46" 0.0)
  fpPin("smd_r950x500" 7.405 4.8 "47" 0.0)
  fpPin("smd_r950x500" 7.405 5.6 "48" 0.0)
  fpPin("smd_r2250x1735" 7.015 7.275 "49" 90.0)
  fpPin("smd_r950x500" 5.5975 7.925 "50" 90.0)
  fpPin("smd_r950x500" 4.7975 7.925 "51" 90.0)
  fpPin("smd_r950x500" 3.9975 7.925 "52" 90.0)
  fpPin("smd_r950x500" 3.1975 7.925 "53" 90.0)
  fpPin("smd_r950x500" 2.3975 7.925 "54" 90.0)
  fpPin("smd_r950x500" 1.5975 7.925 "55" 90.0)
  fpPin("smd_r950x500" 0.7975 7.925 "56" 90.0)
  fpPin("smd_r950x500" -0.0025 7.925 "57" 90.0)
  fpPin("smd_r950x500" -0.8025 7.925 "58" 90.0)
  fpPin("smd_r950x500" -1.6025 7.925 "59" 90.0)
  fpPin("smd_r950x500" -2.4025 7.925 "60" 90.0)
  fpPin("smd_r950x500" -3.2025 7.925 "61" 90.0)
  fpPin("smd_r950x500" -4.0025 7.925 "62" 90.0)
  fpPin("smd_r950x500" -4.8025 7.925 "63" 90.0)
  fpPin("smd_r950x500" -5.6025 7.925 "64" 90.0)
  fpPin("smd_r2950x800" 5.145 5.38 "65" 90.0)
  fpPin("smd_r2300x1330p00" 4.155 1.44 "66" 0.0)
  fpPin("smd_r2300x2250p00" 4.155 -1.895 "67" 0.0)
  fpPin("smd_r4720x2800" -0.005 5.455 "68" 0.0)
  fpPin("smd_r4720x2250" -0.005 1.895 "69" 0.0)
  fpPin("smd_r4720x2250" -0.005 -1.895 "70" 0.0)
  fpPin("smd_r4720x2800" -0.005 -5.445 "71" 0.0)
  fpPin("smd_r2300x2250p00" -4.165 -1.895 "72" 0.0)
  fpLine("PACKAGE GEOMETRY/ASSEMBLY_TOP" list(list(-7.575 8.075) list(7.575 8.075)) 0.0)
  fpLine("PACKAGE GEOMETRY/ASSEMBLY_TOP" list(list(-7.575 -8.075) list(7.575 -8.075)) 0.0)
  fpLine("PACKAGE GEOMETRY/ASSEMBLY_TOP" list(list(7.575 -8.075) list(7.575 8.075)) 0.0)
  fpLine("PACKAGE GEOMETRY/ASSEMBLY_TOP" list(list(-7.575 -8.075) list(-7.575 8.075)) 0.0)
  fpLine("PACKAGE GEOMETRY/SILKSCREEN_TOP" list(list(-8.15 6.5) list(-8.15 8.65)) 0.12)
  fpLine("PACKAGE GEOMETRY/SILKSCREEN_TOP" list(list(-8.15 8.65) list(-6.4 8.65)) 0.12)
  fpPoly("PACKAGE GEOMETRY/PASTEMASK_TOP" list(list(0.145 1.745) list(0.145 0.795) list(2.335 0.795) list(2.335 1.745) list(0.145 1.745)))
  fpPoly("PACKAGE GEOMETRY/PASTEMASK_TOP" list(list(0.145 2.995) list(0.145 2.045) list(2.335 2.045) list(2.335 2.995) list(0.145 2.995)))
  fpPoly("PACKAGE GEOMETRY/PASTEMASK_TOP" list(list(-2.345 1.745) list(-2.345 0.795) list(-0.155 0.795) list(-0.155 1.745) list(-2.345 1.745)))
  fpPoly("PACKAGE GEOMETRY/PASTEMASK_TOP" list(list(-2.345 2.995) list(-2.345 2.045) list(-0.155 2.045) list(-0.155 2.995) list(-2.345 2.995)))
  fpPoly("PACKAGE GEOMETRY/PASTEMASK_TOP" list(list(4.305 -0.795) list(4.305 -1.745) list(5.285 -1.745) list(5.285 -0.795) list(4.305 -0.795)))
  fpPoly("PACKAGE GEOMETRY/PASTEMASK_TOP" list(list(4.305 -2.045) list(4.305 -2.995) list(5.285 -2.995) list(5.285 -2.045) list(4.305 -2.045)))
  fpPoly("PACKAGE GEOMETRY/PASTEMASK_TOP" list(list(3.025 -2.045) list(3.025 -2.995) list(4.005 -2.995) list(4.005 -2.045) list(3.025 -2.045)))
  fpPoly("PACKAGE GEOMETRY/PASTEMASK_TOP" list(list(3.025 -0.795) list(3.025 -1.745) list(4.005 -1.745) list(4.005 -0.795) list(3.025 -0.795)))
  fpPoly("PACKAGE GEOMETRY/PASTEMASK_TOP" list(list(-5.295 -0.795) list(-5.295 -1.745) list(-4.315 -1.745) list(-4.315 -0.795) list(-5.295 -0.795)))
  fpPoly("PACKAGE GEOMETRY/PASTEMASK_TOP" list(list(-5.295 -2.045) list(-5.295 -2.995) list(-4.315 -2.995) list(-4.315 -2.045) list(-5.295 -2.045)))
  fpPoly("PACKAGE GEOMETRY/PASTEMASK_TOP" list(list(-4.015 -2.045) list(-4.015 -2.995) list(-3.035 -2.995) list(-3.035 -2.045) list(-4.015 -2.045)))
  fpPoly("PACKAGE GEOMETRY/PASTEMASK_TOP" list(list(-4.015 -0.795) list(-4.015 -1.745) list(-3.035 -1.745) list(-3.035 -0.795) list(-4.015 -0.795)))
  fpPoly("PACKAGE GEOMETRY/PASTEMASK_TOP" list(list(-2.345 -0.795) list(-2.345 -1.745) list(-0.155 -1.745) list(-0.155 -0.795) list(-2.345 -0.795)))
  fpPoly("PACKAGE GEOMETRY/PASTEMASK_TOP" list(list(-2.345 -2.045) list(-2.345 -2.995) list(-0.155 -2.995) list(-0.155 -2.045) list(-2.345 -2.045)))
  fpPoly("PACKAGE GEOMETRY/PASTEMASK_TOP" list(list(0.145 -0.795) list(0.145 -1.745) list(2.335 -1.745) list(2.335 -0.795) list(0.145 -0.795)))
  fpPoly("PACKAGE GEOMETRY/PASTEMASK_TOP" list(list(0.145 -2.045) list(0.145 -2.995) list(2.335 -2.995) list(2.335 -2.045) list(0.145 -2.045)))
  fpPoly("PACKAGE GEOMETRY/PASTEMASK_TOP" list(list(-2.345 -4.065) list(-2.345 -5.295) list(-0.155 -5.295) list(-0.155 -4.065) list(-2.345 -4.065)))
  fpPoly("PACKAGE GEOMETRY/PASTEMASK_TOP" list(list(0.145 -4.065) list(0.145 -5.295) list(2.335 -5.295) list(2.335 -4.065) list(0.145 -4.065)))
  fpPoly("PACKAGE GEOMETRY/PASTEMASK_TOP" list(list(0.145 -5.595) list(0.145 -6.825) list(2.335 -6.825) list(2.335 -5.595) list(0.145 -5.595)))
  fpPoly("PACKAGE GEOMETRY/PASTEMASK_TOP" list(list(-2.345 -5.595) list(-2.345 -6.825) list(-0.155 -6.825) list(-0.155 -5.595) list(-2.345 -5.595)))
  fpPoly("PACKAGE GEOMETRY/PASTEMASK_TOP" list(list(-2.345 5.305) list(-2.345 4.075) list(-0.155 4.075) list(-0.155 5.305) list(-2.345 5.305)))
  fpPoly("PACKAGE GEOMETRY/PASTEMASK_TOP" list(list(0.145 5.305) list(0.145 4.075) list(2.335 4.075) list(2.335 5.305) list(0.145 5.305)))
  fpPoly("PACKAGE GEOMETRY/PASTEMASK_TOP" list(list(0.145 6.835) list(0.145 5.605) list(2.335 5.605) list(2.335 6.835) list(0.145 6.835)))
  fpPoly("PACKAGE GEOMETRY/PASTEMASK_TOP" list(list(-2.345 6.835) list(-2.345 5.605) list(-0.155 5.605) list(-0.155 6.835) list(-2.345 6.835)))
  fpPoly("PACKAGE GEOMETRY/PASTEMASK_TOP" list(list(3.025 1.29) list(3.025 0.8) list(4.005 0.8) list(4.005 1.29) list(3.025 1.29)))
  fpPoly("PACKAGE GEOMETRY/PASTEMASK_TOP" list(list(4.305 2.08) list(4.305 1.59) list(5.285 1.59) list(5.285 2.08) list(4.305 2.08)))
  fpPoly("PACKAGE GEOMETRY/PASTEMASK_TOP" list(list(4.305 1.29) list(4.305 0.8) list(5.285 0.8) list(5.285 1.29) list(4.305 1.29)))
  fpPoly("PACKAGE GEOMETRY/PASTEMASK_TOP" list(list(3.025 2.08) list(3.025 1.59) list(4.005 1.59) list(4.005 2.08) list(3.025 2.08)))
  fpPoly("PACKAGE GEOMETRY/PASTEMASK_TOP" list(list(4.77 6.76) list(4.77 5.53) list(5.52 5.53) list(5.52 6.76) list(4.77 6.76)))
  fpPoly("PACKAGE GEOMETRY/PASTEMASK_TOP" list(list(4.77 5.23) list(4.77 4.0) list(5.52 4.0) list(5.52 5.23) list(4.77 5.23)))
  fpPoly("PACKAGE GEOMETRY/PASTEMASK_TOP" list(list(-7.65 8.17) list(-7.65 6.37) list(-7.28 6.37) list(-6.37 7.28) list(-6.37 8.17) list(-7.65 8.17)))
  axlDBCreateText("U*" list(0.0 0.0) fpTxt(2) "REF DES/SILKSCREEN_TOP")
  fpEnd("qfn72-16r15x15r15-_8" "U*" -8.133 -8.65 8.133 8.65 list("smd_s1000x1000p00" "smd_r950x500" "smd_r2250x1735" "smd_r2950x800" "smd_r2300x1330p00" "smd_r2300x2250p00" "smd_r4720x2800" "smd_r4720x2250")))

procedure( fp_8()
  fpBegin("m2_mkey_2280")
  fpSMD("smd_r305x1549" 'RECTANGLE 0.3048 1.5494 0.3048 1.5494 t)
  fpSMD("smd_r1194x2743" 'RECTANGLE 1.1938 2.7432 1.1938 2.7432 t)
  fpNPTH("npth_1092" 1.0922)
  fpNPTH("npth_1600" 1.6002)
  fpSMD("smd_c200x200p00nm" 'CIRCLE 0.2 0.2 0.0 0.0 nil)
  fpPin("smd_r305x1549" -18.5 7.55 "1" 0.0)
  fpPin("smd_r305x1549" -18.25 0.0 "2" 0.0)
  fpPin("smd_r305x1549" -18.0 7.55 "3" 0.0)
  fpPin("smd_r305x1549" -17.75 0.0 "4" 0.0)
  fpPin("smd_r305x1549" -17.5 7.55 "5" 0.0)
  fpPin("smd_r305x1549" -17.25 0.0 "6" 0.0)
  fpPin("smd_r305x1549" -17.0 7.55 "7" 0.0)
  fpPin("smd_r305x1549" -16.75 0.0 "8" 0.0)
  fpPin("smd_r305x1549" -16.5 7.55 "9" 0.0)
  fpPin("smd_r305x1549" -16.25 0.0 "10" 0.0)
  fpPin("smd_r305x1549" -16.0 7.55 "11" 0.0)
  fpPin("smd_r305x1549" -15.75 0.0 "12" 0.0)
  fpPin("smd_r305x1549" -15.5 7.55 "13" 0.0)
  fpPin("smd_r305x1549" -15.25 0.0 "14" 0.0)
  fpPin("smd_r305x1549" -15.0 7.55 "15" 0.0)
  fpPin("smd_r305x1549" -14.75 0.0 "16" 0.0)
  fpPin("smd_r305x1549" -14.5 7.55 "17" 0.0)
  fpPin("smd_r305x1549" -14.25 0.0 "18" 0.0)
  fpPin("smd_r305x1549" -14.0 7.55 "19" 0.0)
  fpPin("smd_r305x1549" -13.75 0.0 "20" 0.0)
  fpPin("smd_r305x1549" -13.5 7.55 "21" 0.0)
  fpPin("smd_r305x1549" -13.25 0.0 "22" 0.0)
  fpPin("smd_r305x1549" -13.0 7.55 "23" 0.0)
  fpPin("smd_r305x1549" -12.75 0.0 "24" 0.0)
  fpPin("smd_r305x1549" -12.5 7.55 "25" 0.0)
  fpPin("smd_r305x1549" -12.25 0.0 "26" 0.0)
  fpPin("smd_r305x1549" -12.0 7.55 "27" 0.0)
  fpPin("smd_r305x1549" -11.75 0.0 "28" 0.0)
  fpPin("smd_r305x1549" -11.5 7.55 "29" 0.0)
  fpPin("smd_r305x1549" -11.25 0.0 "30" 0.0)
  fpPin("smd_r305x1549" -11.0 7.55 "31" 0.0)
  fpPin("smd_r305x1549" -10.75 0.0 "32" 0.0)
  fpPin("smd_r305x1549" -10.5 7.55 "33" 0.0)
  fpPin("smd_r305x1549" -10.25 0.0 "34" 0.0)
  fpPin("smd_r305x1549" -10.0 7.55 "35" 0.0)
  fpPin("smd_r305x1549" -9.75 0.0 "36" 0.0)
  fpPin("smd_r305x1549" -9.5 7.55 "37" 0.0)
  fpPin("smd_r305x1549" -9.25 0.0 "38" 0.0)
  fpPin("smd_r305x1549" -9.0 7.55 "39" 0.0)
  fpPin("smd_r305x1549" -8.75 0.0 "40" 0.0)
  fpPin("smd_r305x1549" -8.5 7.55 "41" 0.0)
  fpPin("smd_r305x1549" -8.25 0.0 "42" 0.0)
  fpPin("smd_r305x1549" -8.0 7.55 "43" 0.0)
  fpPin("smd_r305x1549" -7.75 0.0 "44" 0.0)
  fpPin("smd_r305x1549" -7.5 7.55 "45" 0.0)
  fpPin("smd_r305x1549" -7.25 0.0 "46" 0.0)
  fpPin("smd_r305x1549" -7.0 7.55 "47" 0.0)
  fpPin("smd_r305x1549" -6.75 0.0 "48" 0.0)
  fpPin("smd_r305x1549" -6.5 7.55 "49" 0.0)
  fpPin("smd_r305x1549" -6.25 0.0 "50" 0.0)
  fpPin("smd_r305x1549" -6.0 7.55 "51" 0.0)
  fpPin("smd_r305x1549" -5.75 0.0 "52" 0.0)
  fpPin("smd_r305x1549" -5.5 7.55 "53" 0.0)
  fpPin("smd_r305x1549" -5.25 0.0 "54" 0.0)
  fpPin("smd_r305x1549" -5.0 7.55 "55" 0.0)
  fpPin("smd_r305x1549" -4.75 0.0 "56" 0.0)
  fpPin("smd_r305x1549" -4.5 7.55 "57" 0.0)
  fpPin("smd_r305x1549" -4.25 0.0 "58" 0.0)
  fpPin("smd_r305x1549" -2.0 7.55 "67" 0.0)
  fpPin("smd_r305x1549" -1.75 0.0 "68" 0.0)
  fpPin("smd_r305x1549" -1.5 7.55 "69" 0.0)
  fpPin("smd_r305x1549" -1.25 0.0 "70" 0.0)
  fpPin("smd_r305x1549" -1.0 7.55 "71" 0.0)
  fpPin("smd_r305x1549" -0.75 0.0 "72" 0.0)
  fpPin("smd_r305x1549" -0.5 7.55 "73" 0.0)
  fpPin("smd_r305x1549" -0.25 0.0 "74" 0.0)
  fpPin("smd_r305x1549" 0.0 7.55 "75" 0.0)
  fpPin("smd_r1194x2743" -19.6 6.775 "76" 0.0)
  fpPin("smd_r1194x2743" 1.1 6.775 nil 0.0)
  fpPin("npth_1092" -19.25 2.275 nil 0.0)
  fpPin("npth_1600" 0.75 2.275 nil 0.0)
  fpPin("smd_c200x200p00nm" -4.0 7.55 "59" 0.0)
  fpPin("smd_c200x200p00nm" -3.75 0.0 "60" 0.0)
  fpPin("smd_c200x200p00nm" -3.5 7.55 "61" 0.0)
  fpPin("smd_c200x200p00nm" -3.25 0.0 "62" 0.0)
  fpPin("smd_c200x200p00nm" -3.0 7.55 "63" 0.0)
  fpPin("smd_c200x200p00nm" -2.75 0.0 "64" 0.0)
  fpPin("smd_c200x200p00nm" -2.5 7.55 "65" 0.0)
  fpPin("smd_c200x200p00nm" -2.25 0.0 "66" 0.0)
  fpLine("PACKAGE GEOMETRY/ASSEMBLY_TOP" list(list(-20.1974 -0.5811) list(1.6974 -0.5811)) 0.0)
  fpLine("PACKAGE GEOMETRY/ASSEMBLY_TOP" list(list(1.6974 -0.5811) list(1.6974 8.1311)) 0.0)
  fpLine("PACKAGE GEOMETRY/ASSEMBLY_TOP" list(list(1.6974 8.1311) list(-20.1974 8.1311)) 0.0)
  fpLine("PACKAGE GEOMETRY/ASSEMBLY_TOP" list(list(-20.1974 8.1311) list(-20.1974 -0.5811)) 0.0)
  fpLine("PACKAGE GEOMETRY/SILKSCREEN_TOP" list(list(-20.3244 5.0961) list(-20.3244 -0.7081)) 0.12)
  fpLine("PACKAGE GEOMETRY/SILKSCREEN_TOP" list(list(-20.3244 -0.7081) list(-18.7351 -0.7081)) 0.12)
  fpLine("PACKAGE GEOMETRY/SILKSCREEN_TOP" list(list(1.8244 -0.7081) list(1.8244 1.9158)) 0.12)
  fpLine("PACKAGE GEOMETRY/SILKSCREEN_TOP" list(list(-2.4851 8.2581) list(-4.0149 8.2581)) 0.12)
  fpLine("PACKAGE GEOMETRY/SILKSCREEN_TOP" list(list(0.2351 -0.7081) list(1.8244 -0.7081)) 0.12)
  fpLine("PACKAGE GEOMETRY/SILKSCREEN_TOP" list(list(-3.7649 -0.7081) list(-2.2351 -0.7081)) 0.12)
  fpLine("PACKAGE GEOMETRY/SILKSCREEN_TOP" list(list(1.8244 2.6342) list(1.8244 5.0961)) 0.12)
  axlDBCreateText("U*" list(-9.25 3.775) fpTxt(2) "REF DES/SILKSCREEN_TOP")
  fpEnd("m2_mkey_2280" "U*" -20.4514 -1.0287 1.9514 8.5787 list("smd_r305x1549" "smd_r1194x2743" "npth_1092" "npth_1600" "smd_c200x200p00nm")))

procedure( fp_all()
  fpLogPort = outfile("fp_gen.log" "w")
  unless(errset(fp_0() t) fpLog("  FALLO SKILL en fp_0"))
  unless(errset(fp_1() t) fpLog("  FALLO SKILL en fp_1"))
  unless(errset(fp_2() t) fpLog("  FALLO SKILL en fp_2"))
  unless(errset(fp_3() t) fpLog("  FALLO SKILL en fp_3"))
  unless(errset(fp_4() t) fpLog("  FALLO SKILL en fp_4"))
  unless(errset(fp_5() t) fpLog("  FALLO SKILL en fp_5"))
  unless(errset(fp_6() t) fpLog("  FALLO SKILL en fp_6"))
  unless(errset(fp_7() t) fpLog("  FALLO SKILL en fp_7"))
  unless(errset(fp_8() t) fpLog("  FALLO SKILL en fp_8"))
  fpLog("fin")
  close(fpLogPort) fpLogPort = nil
  axlOpenDesign(?design "fp_blank.dra" ?mode "wf"))
