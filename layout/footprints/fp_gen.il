;; fp_gen.il  --  generado por gen_fp.py (no editar a mano)
;; Uso (Allegro, con fp_blank.dra abierto en 03 Layout\lib):
;;   skill load("../scripts/fp_gen.il")
;;   skill fp_all()
fpLogPort = nil
fpErrs = 0
procedure( fpLog(msg)
  when(fpLogPort fprintf(fpLogPort "%s\n" msg) drain(fpLogPort))
  printf("%s\n" msg))
procedure( fpErr(msg) fpErrs = fpErrs + 1 fpLog(strcat("  ERROR: " msg)))
procedure( fpTxt(tb) make_axlTextOrientation(?textBlock tb ?rotation 0.0 ?mirrored nil ?justify "center"))

procedure( fpBegin(name)
  let((u)
    fpErrs = 0
    fpLog(strcat("== " name))
    unless(axlOpenDesign(?design "fp_blank.dra" ?mode "wf") fpErr("no abre fp_blank.dra"))
    axlSetSymbolType("package")
    u = axlDBGetDesignUnits()
    when(listp(u) u = car(u))
    when(stringp(u) u = lowerCase(u))
    unless(u == "millimeters"
      unless(axlDBChangeDesignUnits("millimeters" 4)
        unless(axlDBChangeDesignUnits("millimeters" nil) fpErr("no cambia unidades a mm"))))
    fpLog(sprintf(nil "  unidades: %L" axlDBGetDesignUnits()))
    unless(axlDBChangeDesignExtents(list(list(-120.0 -120.0) list(120.0 120.0))) fpErr("extents"))))

procedure( fpSMD(name fig w h pw ph masked)
  let((pads r)
    pads = list(make_axlPadStackPad(?layer "TOP" ?type 'REGULAR ?figure fig ?figureSize list(w h)))
    when(masked
      pads = cons(make_axlPadStackPad(?layer "SOLDER0.05_TOP" ?type 'REGULAR ?figure fig
                    ?figureSize list(w+2*0.05 h+2*0.05)) pads))
    when(pw > 0.0
      pads = cons(make_axlPadStackPad(?layer "PASTE0.05_TOP" ?type 'REGULAR ?figure fig
                    ?figureSize list(pw ph)) pads))
    r = axlDBCreatePadStack(name nil pads t)
    unless(r fpErr(strcat("padstack " name)))
    r))

procedure( fpNPTH(name d)
  let((dr pads r)
    dr = make_axlPadStackDrill(?holeType 'CIRCLE_DRILL ?drillDiameter d ?plating 'NON_PLATED
                               ?figure 'CIRCLE ?figureSize list(d d) ?drillChar "N")
    pads = list(make_axlPadStackPad(?layer "SOLDER0.05_TOP" ?type 'REGULAR ?figure 'CIRCLE ?figureSize list(d+0.2 d+0.2))
                make_axlPadStackPad(?layer "SOLDER0.05_BOTTOM" ?type 'REGULAR ?figure 'CIRCLE ?figureSize list(d+0.2 d+0.2)))
    r = axlDBCreatePadStack(name dr pads t)
    unless(r fpErr(strcat("padstack " name)))
    r))

procedure( fpPin(ps x y num rot)
  let((pt r)
    pt = if(num make_axlPinText(?number num ?offset list(0.0 0.0) ?text fpTxt(1)) nil)
    r = axlDBCreatePin(ps list(x y) pt rot)
    unless(r fpErr(sprintf(nil "pin %L en %L %L" num x y)))
    r))

procedure( fpLine(layer pts w)
  unless(axlDBCreateLine(pts w layer) fpErr(strcat("linea " layer))))

procedure( fpEnd(name ref x1 y1 x2 y2 pss)
  let((s c)
    unless(axlDBCreateRectangle(list(list(x1 y1) list(x2 y2)) t "PACKAGE GEOMETRY/PLACE_BOUND_TOP")
      fpErr("place bound"))
    unless(axlDBCreateText(ref list(0.0 0.0) fpTxt(2) "REF DES/ASSEMBLY_TOP") fpErr("refdes asm"))
    s = axlSaveDesign(?design name ?noConfirm t)
    c = axlCompileSymbol(?symbol name ?silent t ?silentOnOverwrite t)
    foreach(p pss unless(axlPadstackToDisk(p) fpErr(strcat("pad a disco " p))))
    fpLog(sprintf(nil "  save=%L psm=%L errores=%d" s c fpErrs))))

procedure( fp_0()
  fpBegin("so14-6-1_27")
  fpSMD("smd_r195x060" 'RECTANGLE 1.95 0.6 1.95 0.6 t)
  fpPin("smd_r195x060" -2.475 3.81 "1" 0.0)
  fpPin("smd_r195x060" -2.475 2.54 "2" 0.0)
  fpPin("smd_r195x060" -2.475 1.27 "3" 0.0)
  fpPin("smd_r195x060" -2.475 0.0 "4" 0.0)
  fpPin("smd_r195x060" -2.475 -1.27 "5" 0.0)
  fpPin("smd_r195x060" -2.475 -2.54 "6" 0.0)
  fpPin("smd_r195x060" -2.475 -3.81 "7" 0.0)
  fpPin("smd_r195x060" 2.475 -3.81 "8" 0.0)
  fpPin("smd_r195x060" 2.475 -2.54 "9" 0.0)
  fpPin("smd_r195x060" 2.475 -1.27 "10" 0.0)
  fpPin("smd_r195x060" 2.475 0.0 "11" 0.0)
  fpPin("smd_r195x060" 2.475 1.27 "12" 0.0)
  fpPin("smd_r195x060" 2.475 2.54 "13" 0.0)
  fpPin("smd_r195x060" 2.475 3.81 "14" 0.0)
  fpLine("PACKAGE GEOMETRY/SILKSCREEN_TOP" list(list(0.0 -4.435) list(1.95 -4.435)) 0.12)
  fpLine("PACKAGE GEOMETRY/SILKSCREEN_TOP" list(list(0.0 -4.435) list(-1.95 -4.435)) 0.12)
  fpLine("PACKAGE GEOMETRY/SILKSCREEN_TOP" list(list(0.0 4.435) list(1.95 4.435)) 0.12)
  fpLine("PACKAGE GEOMETRY/SILKSCREEN_TOP" list(list(0.0 4.435) list(-3.45 4.435)) 0.12)
  fpLine("PACKAGE GEOMETRY/ASSEMBLY_TOP" list(list(-0.975 4.325) list(1.95 4.325)) 0.0)
  fpLine("PACKAGE GEOMETRY/ASSEMBLY_TOP" list(list(1.95 4.325) list(1.95 -4.325)) 0.0)
  fpLine("PACKAGE GEOMETRY/ASSEMBLY_TOP" list(list(1.95 -4.325) list(-1.95 -4.325)) 0.0)
  fpLine("PACKAGE GEOMETRY/ASSEMBLY_TOP" list(list(-1.95 -4.325) list(-1.95 3.35)) 0.0)
  fpLine("PACKAGE GEOMETRY/ASSEMBLY_TOP" list(list(-1.95 3.35) list(-0.975 4.325)) 0.0)
  axlDBCreateText("U*" list(0.0 5.28) fpTxt(2) "REF DES/SILKSCREEN_TOP")
  fpEnd("so14-6-1_27" "U*" -3.7 -4.58 3.7 4.58 list("smd_r195x060")))

procedure( fp_1()
  fpBegin("tssop20-6_5-_65")
  fpSMD("smd_r148x040" 'RECTANGLE 1.475 0.4 1.475 0.4 t)
  fpPin("smd_r148x040" -2.8625 2.925 "1" 0.0)
  fpPin("smd_r148x040" -2.8625 2.275 "2" 0.0)
  fpPin("smd_r148x040" -2.8625 1.625 "3" 0.0)
  fpPin("smd_r148x040" -2.8625 0.975 "4" 0.0)
  fpPin("smd_r148x040" -2.8625 0.325 "5" 0.0)
  fpPin("smd_r148x040" -2.8625 -0.325 "6" 0.0)
  fpPin("smd_r148x040" -2.8625 -0.975 "7" 0.0)
  fpPin("smd_r148x040" -2.8625 -1.625 "8" 0.0)
  fpPin("smd_r148x040" -2.8625 -2.275 "9" 0.0)
  fpPin("smd_r148x040" -2.8625 -2.925 "10" 0.0)
  fpPin("smd_r148x040" 2.8625 -2.925 "11" 0.0)
  fpPin("smd_r148x040" 2.8625 -2.275 "12" 0.0)
  fpPin("smd_r148x040" 2.8625 -1.625 "13" 0.0)
  fpPin("smd_r148x040" 2.8625 -0.975 "14" 0.0)
  fpPin("smd_r148x040" 2.8625 -0.325 "15" 0.0)
  fpPin("smd_r148x040" 2.8625 0.325 "16" 0.0)
  fpPin("smd_r148x040" 2.8625 0.975 "17" 0.0)
  fpPin("smd_r148x040" 2.8625 1.625 "18" 0.0)
  fpPin("smd_r148x040" 2.8625 2.275 "19" 0.0)
  fpPin("smd_r148x040" 2.8625 2.925 "20" 0.0)
  fpLine("PACKAGE GEOMETRY/SILKSCREEN_TOP" list(list(0.0 -3.385) list(2.2 -3.385)) 0.12)
  fpLine("PACKAGE GEOMETRY/SILKSCREEN_TOP" list(list(0.0 -3.385) list(-2.2 -3.385)) 0.12)
  fpLine("PACKAGE GEOMETRY/SILKSCREEN_TOP" list(list(0.0 3.385) list(2.2 3.385)) 0.12)
  fpLine("PACKAGE GEOMETRY/SILKSCREEN_TOP" list(list(0.0 3.385) list(-3.6 3.385)) 0.12)
  fpLine("PACKAGE GEOMETRY/ASSEMBLY_TOP" list(list(-1.2 3.25) list(2.2 3.25)) 0.0)
  fpLine("PACKAGE GEOMETRY/ASSEMBLY_TOP" list(list(2.2 3.25) list(2.2 -3.25)) 0.0)
  fpLine("PACKAGE GEOMETRY/ASSEMBLY_TOP" list(list(2.2 -3.25) list(-2.2 -3.25)) 0.0)
  fpLine("PACKAGE GEOMETRY/ASSEMBLY_TOP" list(list(-2.2 -3.25) list(-2.2 2.25)) 0.0)
  fpLine("PACKAGE GEOMETRY/ASSEMBLY_TOP" list(list(-2.2 2.25) list(-1.2 3.25)) 0.0)
  axlDBCreateText("U*" list(0.0 4.2) fpTxt(2) "REF DES/SILKSCREEN_TOP")
  fpEnd("tssop20-6_5-_65" "U*" -3.85 -3.5 3.85 3.5 list("smd_r148x040")))

procedure( fp_2()
  fpBegin("l1812")
  fpSMD("smd_r112x340" 'RECTANGLE 1.125 3.4 1.125 3.4 t)
  fpPin("smd_r112x340" -2.1375 0.0 "1" 0.0)
  fpPin("smd_r112x340" 2.1375 0.0 "2" 0.0)
  fpLine("PACKAGE GEOMETRY/ASSEMBLY_TOP" list(list(-2.25 -1.6) list(-2.25 1.6)) 0.0)
  fpLine("PACKAGE GEOMETRY/ASSEMBLY_TOP" list(list(-2.25 1.6) list(2.25 1.6)) 0.0)
  fpLine("PACKAGE GEOMETRY/ASSEMBLY_TOP" list(list(2.25 1.6) list(2.25 -1.6)) 0.0)
  fpLine("PACKAGE GEOMETRY/ASSEMBLY_TOP" list(list(2.25 -1.6) list(-2.25 -1.6)) 0.0)
  fpLine("PACKAGE GEOMETRY/SILKSCREEN_TOP" list(list(-1.3863 1.71) list(1.3863 1.71)) 0.12)
  fpLine("PACKAGE GEOMETRY/SILKSCREEN_TOP" list(list(-1.3863 -1.71) list(1.3863 -1.71)) 0.12)
  axlDBCreateText("U*" list(0.0 2.65) fpTxt(2) "REF DES/SILKSCREEN_TOP")
  fpEnd("l1812" "U*" -2.95 -1.95 2.95 1.95 list("smd_r112x340")))

procedure( fp_3()
  fpBegin("7_3x4_3x2_8")
  fpSMD("smd_r208x255" 'RECTANGLE 2.075 2.55 2.075 2.55 t)
  fpPin("smd_r208x255" -3.1125 0.0 "1" 0.0)
  fpPin("smd_r208x255" 3.1125 0.0 "2" 0.0)
  fpLine("PACKAGE GEOMETRY/ASSEMBLY_TOP" list(list(3.65 2.15) list(-2.65 2.15)) 0.0)
  fpLine("PACKAGE GEOMETRY/ASSEMBLY_TOP" list(list(-2.65 2.15) list(-3.65 1.15)) 0.0)
  fpLine("PACKAGE GEOMETRY/ASSEMBLY_TOP" list(list(-3.65 1.15) list(-3.65 -2.15)) 0.0)
  fpLine("PACKAGE GEOMETRY/ASSEMBLY_TOP" list(list(-3.65 -2.15) list(3.65 -2.15)) 0.0)
  fpLine("PACKAGE GEOMETRY/ASSEMBLY_TOP" list(list(3.65 -2.15) list(3.65 2.15)) 0.0)
  fpLine("PACKAGE GEOMETRY/SILKSCREEN_TOP" list(list(3.65 2.26) list(-4.41 2.26)) 0.12)
  fpLine("PACKAGE GEOMETRY/SILKSCREEN_TOP" list(list(-4.41 2.26) list(-4.41 -2.26)) 0.12)
  fpLine("PACKAGE GEOMETRY/SILKSCREEN_TOP" list(list(-4.41 -2.26) list(3.65 -2.26)) 0.12)
  axlDBCreateText("U*" list(0.0 3.1) fpTxt(2) "REF DES/SILKSCREEN_TOP")
  fpEnd("7_3x4_3x2_8" "U*" -4.4 -2.4 4.4 2.4 list("smd_r208x255")))

procedure( fp_4()
  fpBegin("dfn8-0303-_65")
  fpSMD("smd_r065x030" 'RECTANGLE 0.65 0.3 0.65 0.3 t)
  fpSMD("smd_r160x235p80" 'RECTANGLE 1.6 2.35 1.28 1.88 t)
  fpPin("smd_r065x030" -1.375 0.975 "1" 0.0)
  fpPin("smd_r065x030" 1.375 0.975 "8" 0.0)
  fpPin("smd_r065x030" -1.375 0.325 "2" 0.0)
  fpPin("smd_r065x030" 1.375 0.325 "7" 0.0)
  fpPin("smd_r065x030" -1.375 -0.325 "3" 0.0)
  fpPin("smd_r065x030" 1.375 -0.325 "6" 0.0)
  fpPin("smd_r065x030" -1.375 -0.975 "4" 0.0)
  fpPin("smd_r065x030" 1.375 -0.975 "5" 0.0)
  fpPin("smd_r160x235p80" 0.0 0.0 "9" 0.0)
  fpLine("PACKAGE GEOMETRY/ASSEMBLY_TOP" list(list(-1.5 1.5) list(1.5 1.5) list(1.5 -1.5) list(-1.5 -1.5) list(-1.5 1.5)) 0.0)
  fpLine("PACKAGE GEOMETRY/SILKSCREEN_TOP" list(list(-0.9 1.62) list(0.9 1.62)) 0.12)
  fpLine("PACKAGE GEOMETRY/SILKSCREEN_TOP" list(list(-0.9 -1.62) list(0.9 -1.62)) 0.12)
  fpLine("PACKAGE GEOMETRY/SILKSCREEN_TOP" list(list(-2.05 1.55) list(-2.05 1.25)) 0.12)
  axlDBCreateText("U*" list(0.0 2.3) fpTxt(2) "REF DES/SILKSCREEN_TOP")
  fpEnd("dfn8-0303-_65" "U*" -2.0 -1.75 2.0 1.75 list("smd_r065x030" "smd_r160x235p80")))

procedure( fp_5()
  fpBegin("455580003")
  fpNPTH("npth_320" 3.2)
  fpPin("pad100cir70ds105" 0.0 0.0 "1" 0.0)
  fpPin("pad100cir70ds105" 4.2 0.0 "2" 0.0)
  fpPin("pad100cir70ds105" 8.4 0.0 "3" 0.0)
  fpPin("pad100cir70ds105" 0.0 -5.5 "4" 0.0)
  fpPin("pad100cir70ds105" 4.2 -5.5 "5" 0.0)
  fpPin("pad100cir70ds105" 8.4 -5.5 "6" 0.0)
  fpPin("npth_320" -4.5 4.2 nil 0.0)
  fpPin("npth_320" 12.9 4.2 nil 0.0)
  fpLine("PACKAGE GEOMETRY/ASSEMBLY_TOP" list(list(-2.7 13.9) list(-2.7 1.1)) 0.0)
  fpLine("PACKAGE GEOMETRY/ASSEMBLY_TOP" list(list(-2.7 1.1) list(11.1 1.1)) 0.0)
  fpLine("PACKAGE GEOMETRY/ASSEMBLY_TOP" list(list(11.1 1.1) list(11.1 13.9)) 0.0)
  fpLine("PACKAGE GEOMETRY/ASSEMBLY_TOP" list(list(11.1 13.9) list(-2.7 13.9)) 0.0)
  fpLine("PACKAGE GEOMETRY/ASSEMBLY_TOP" list(list(-2.7 7.3) list(-7.7 7.3)) 0.0)
  fpLine("PACKAGE GEOMETRY/ASSEMBLY_TOP" list(list(-7.7 7.3) list(-7.7 1.1)) 0.0)
  fpLine("PACKAGE GEOMETRY/ASSEMBLY_TOP" list(list(-7.7 1.1) list(-2.7 1.1)) 0.0)
  fpLine("PACKAGE GEOMETRY/ASSEMBLY_TOP" list(list(11.1 7.3) list(16.1 7.3)) 0.0)
  fpLine("PACKAGE GEOMETRY/ASSEMBLY_TOP" list(list(16.1 7.3) list(16.1 1.1)) 0.0)
  fpLine("PACKAGE GEOMETRY/ASSEMBLY_TOP" list(list(16.1 1.1) list(11.1 1.1)) 0.0)
  fpLine("PACKAGE GEOMETRY/SILKSCREEN_TOP" list(list(4.2 14.01) list(-2.81 14.01)) 0.12)
  fpLine("PACKAGE GEOMETRY/SILKSCREEN_TOP" list(list(-2.81 14.01) list(-2.81 7.41)) 0.12)
  fpLine("PACKAGE GEOMETRY/SILKSCREEN_TOP" list(list(-2.81 7.41) list(-7.81 7.41)) 0.12)
  fpLine("PACKAGE GEOMETRY/SILKSCREEN_TOP" list(list(-7.81 7.41) list(-7.81 0.99)) 0.12)
  fpLine("PACKAGE GEOMETRY/SILKSCREEN_TOP" list(list(-7.81 0.99) list(-2.0 0.99)) 0.12)
  fpLine("PACKAGE GEOMETRY/SILKSCREEN_TOP" list(list(4.2 14.01) list(11.21 14.01)) 0.12)
  fpLine("PACKAGE GEOMETRY/SILKSCREEN_TOP" list(list(11.21 14.01) list(11.21 7.41)) 0.12)
  fpLine("PACKAGE GEOMETRY/SILKSCREEN_TOP" list(list(11.21 7.41) list(16.21 7.41)) 0.12)
  fpLine("PACKAGE GEOMETRY/SILKSCREEN_TOP" list(list(16.21 7.41) list(16.21 0.99)) 0.12)
  fpLine("PACKAGE GEOMETRY/SILKSCREEN_TOP" list(list(16.21 0.99) list(10.4 0.99)) 0.12)
  fpLine("PACKAGE GEOMETRY/SILKSCREEN_TOP" list(list(-0.3 -2.11) list(-0.3 -3.39)) 0.12)
  fpLine("PACKAGE GEOMETRY/SILKSCREEN_TOP" list(list(0.3 -2.11) list(0.3 -3.39)) 0.12)
  fpLine("PACKAGE GEOMETRY/SILKSCREEN_TOP" list(list(3.9 -2.11) list(3.9 -3.39)) 0.12)
  fpLine("PACKAGE GEOMETRY/SILKSCREEN_TOP" list(list(4.5 -2.11) list(4.5 -3.39)) 0.12)
  fpLine("PACKAGE GEOMETRY/SILKSCREEN_TOP" list(list(8.1 -2.11) list(8.1 -3.39)) 0.12)
  fpLine("PACKAGE GEOMETRY/SILKSCREEN_TOP" list(list(8.7 -2.11) list(8.7 -3.39)) 0.12)
  fpLine("PACKAGE GEOMETRY/SILKSCREEN_TOP" list(list(1.61 1.0) list(2.59 1.0)) 0.12)
  fpLine("PACKAGE GEOMETRY/SILKSCREEN_TOP" list(list(5.81 1.0) list(6.79 1.0)) 0.12)
  fpLine("PACKAGE GEOMETRY/SILKSCREEN_TOP" list(list(-2.0 0.0) list(-2.6 -0.3)) 0.12)
  fpLine("PACKAGE GEOMETRY/SILKSCREEN_TOP" list(list(-2.6 -0.3) list(-2.6 0.3)) 0.12)
  fpLine("PACKAGE GEOMETRY/SILKSCREEN_TOP" list(list(-2.6 0.3) list(-2.0 0.0)) 0.12)
  fpLine("PACKAGE GEOMETRY/ASSEMBLY_TOP" list(list(-1.0 1.1) list(0.0 2.5142)) 0.0)
  fpLine("PACKAGE GEOMETRY/ASSEMBLY_TOP" list(list(0.0 2.5142) list(1.0 1.1)) 0.0)
  axlDBCreateText("U*" list(4.2 15.1) fpTxt(2) "REF DES/SILKSCREEN_TOP")
  fpEnd("455580003" "U*" -8.2 -7.85 16.6 14.4 list("npth_320")))

procedure( fp_all()
  fpLogPort = outfile("fp_gen.log" "w")
  unless(errset(fp_0() t) fpLog("  FALLO SKILL en fp_0"))
  unless(errset(fp_1() t) fpLog("  FALLO SKILL en fp_1"))
  unless(errset(fp_2() t) fpLog("  FALLO SKILL en fp_2"))
  unless(errset(fp_3() t) fpLog("  FALLO SKILL en fp_3"))
  unless(errset(fp_4() t) fpLog("  FALLO SKILL en fp_4"))
  unless(errset(fp_5() t) fpLog("  FALLO SKILL en fp_5"))
  fpLog("fin")
  close(fpLogPort) fpLogPort = nil
  axlOpenDesign(?design "fp_blank.dra" ?mode "wf"))
