;; dpfix.il -- iguala longitudes P/N del upstream (bumps en el diagonal largo del N, hacia afuera del par)
procedure( dpf_del(nets lay)
  let((l)
    l = nil
    foreach(n axlDBGetDesign()->nets
      when(member(n->name nets)
        foreach(b n->branches foreach(o b->children
          when(o->objType == "path" && o->layer == lay l = cons(o l))))))
    printf("borrando %d\n" length(l))
    axlDeleteObject(l)))
procedure( dpf_go()
  dpf_del(list("PERN0_RECEPT" "PERN1_RECEPT" "PERN2_RECEPT" "PERN3_RECEPT") "ETCH/TOP")
  dpf_del(list("PETN0_RECEPT" "PETN1_RECEPT" "PETN2_RECEPT" "PETN3_RECEPT") "ETCH/BOTTOM")
  axlDBCreatePath(axlPathStart(list(list(2185.441 1193.960) list(2185.441 1149.000) list(2176.756 1140.315) list(2176.756 1135.000) list(2176.756 832.278) list(2236.980 772.054) list(2239.957 775.031) list(2252.685 762.303) list(2249.708 759.326) list(2262.436 746.598) list(2265.413 749.575) list(2278.141 736.847) list(2275.164 733.870) list(2287.892 721.142) list(2290.869 724.119) list(2303.597 711.391) list(2300.620 708.414) list(2313.348 695.686) list(2316.325 698.663) list(2329.053 685.935) list(2326.076 682.958) list(2338.804 670.230) list(2341.781 673.207) list(2354.509 660.479) list(2351.532 657.502) list(2411.756 597.278) list(2411.756 75.000) list(2411.756 65.788) list(2428.144 49.400) list(2428.144 -39.365)) 5.400) "ETCH/TOP" "PERN0_RECEPT")
  axlDBCreatePath(axlPathStart(list(list(2224.811 1193.960) list(2224.811 1149.000) list(2216.126 1140.315) list(2216.126 1135.000) list(2216.126 907.278) list(2356.350 767.054) list(2359.476 770.179) list(2372.204 757.451) list(2369.078 754.326) list(2381.806 741.598) list(2384.932 744.723) list(2397.660 731.995) list(2394.534 728.870) list(2407.262 716.142) list(2410.387 719.267) list(2423.115 706.539) list(2419.990 703.414) list(2432.718 690.686) list(2435.843 693.812) list(2448.571 681.084) list(2445.446 677.958) list(2458.174 665.230) list(2461.299 668.356) list(2474.027 655.628) list(2470.902 652.502) list(2611.126 512.278) list(2611.126 75.000) list(2611.126 63.269) list(2624.995 49.400) list(2624.995 -39.365)) 5.400) "ETCH/TOP" "PERN1_RECEPT")
  axlDBCreatePath(axlPathStart(list(list(2303.551 1193.960) list(2303.551 1149.000) list(2294.866 1140.315) list(2294.866 1135.000) list(2294.866 877.278) list(2475.090 697.054) list(2478.286 700.250) list(2491.014 687.522) list(2487.818 684.326) list(2500.546 671.598) list(2503.742 674.794) list(2516.470 662.066) list(2513.274 658.870) list(2526.002 646.142) list(2529.198 649.338) list(2541.926 636.610) list(2538.730 633.414) list(2551.458 620.686) list(2554.654 623.882) list(2567.382 611.154) list(2564.186 607.958) list(2576.914 595.230) list(2580.110 598.426) list(2592.838 585.698) list(2589.642 582.502) list(2769.866 402.278) list(2769.866 75.000) list(2769.866 62.009) list(2782.475 49.400) list(2782.475 -39.365)) 5.400) "ETCH/TOP" "PERN2_RECEPT")
  axlDBCreatePath(axlPathStart(list(list(2342.921 1193.960) list(2342.921 1149.000) list(2334.236 1140.315) list(2334.236 1135.000) list(2334.236 877.278) list(2571.960 639.554) list(2574.980 642.573) list(2587.708 629.845) list(2584.688 626.826) list(2597.416 614.098) list(2600.436 617.117) list(2613.163 604.389) list(2610.144 601.370) list(2622.872 588.642) list(2625.891 591.661) list(2638.619 578.933) list(2635.600 575.914) list(2648.328 563.186) list(2651.347 566.205) list(2664.075 553.478) list(2661.056 550.458) list(2673.784 537.730) list(2676.803 540.750) list(2689.531 528.022) list(2686.512 525.002) list(2924.236 287.278) list(2924.236 75.000) list(2924.236 65.119) list(2939.955 49.400) list(2939.955 -39.365)) 5.400) "ETCH/TOP" "PERN3_RECEPT")
  axlDBCreatePath(axlPathStart(list(list(2165.756 1292.386) list(2154.551 1281.181) list(2154.551 1255.000) list(2154.551 1030.000) list(2154.551 857.278) list(2267.275 744.554) list(2270.493 747.771) list(2283.221 735.043) list(2280.003 731.826) list(2292.731 719.098) list(2295.949 722.315) list(2308.676 709.587) list(2305.459 706.370) list(2318.187 693.642) list(2321.404 696.859) list(2334.132 684.131) list(2330.915 680.914) list(2343.643 668.186) list(2346.860 671.403) list(2359.588 658.676) list(2356.371 655.458) list(2369.099 642.730) list(2372.316 645.948) list(2385.044 633.220) list(2381.827 630.002) list(2494.551 517.278) list(2494.551 470.000) list(2494.551 427.209) list(2507.205 414.555)) 5.400) "ETCH/BOTTOM" "PETN0_RECEPT")
  axlDBCreatePath(axlPathStart(list(list(2205.126 1292.386) list(2205.126 1280.275) list(2186.551 1261.700) list(2186.551 1255.000) list(2186.551 1030.000) list(2186.551 992.278) list(2381.775 797.054) list(2385.000 800.278) list(2397.728 787.550) list(2394.503 784.326) list(2407.231 771.598) list(2410.456 774.822) list(2423.184 762.094) list(2419.959 758.870) list(2432.687 746.142) list(2435.911 749.366) list(2448.639 736.638) list(2445.415 733.414) list(2458.143 720.686) list(2461.367 723.911) list(2474.095 711.183) list(2470.871 707.958) list(2483.599 695.230) list(2486.823 698.455) list(2499.551 685.727) list(2496.327 682.502) list(2691.551 487.278) list(2691.551 470.000) list(2691.551 427.060) list(2704.056 414.555)) 5.400) "ETCH/BOTTOM" "PETN1_RECEPT")
  axlDBCreatePath(axlPathStart(list(list(2323.231 1292.380) list(2314.551 1284.980) list(2314.551 1255.000) list(2314.551 1030.000) list(2314.551 1007.278) list(2522.275 799.554) list(2525.210 802.488) list(2537.938 789.760) list(2535.003 786.826) list(2547.731 774.098) list(2550.666 777.032) list(2563.394 764.304) list(2560.459 761.370) list(2573.187 748.642) list(2576.122 751.576) list(2588.849 738.849) list(2585.915 735.914) list(2598.643 723.186) list(2601.577 726.121) list(2614.305 713.393) list(2611.371 710.458) list(2624.099 697.730) list(2627.033 700.665) list(2639.761 687.937) list(2636.827 685.002) list(2844.551 477.278) list(2844.551 470.000) list(2844.551 431.540) list(2861.536 414.555)) 5.400) "ETCH/BOTTOM" "PETN2_RECEPT")
  axlDBCreatePath(axlPathStart(list(list(2362.602 1292.390) list(2362.602 1286.751) list(2345.551 1269.700) list(2345.551 1255.000) list(2345.551 1030.000) list(2345.551 1022.278) list(2556.664 811.165) list(2559.832 814.332) list(2572.560 801.605) list(2569.392 798.437) list(2582.120 785.709) list(2585.288 788.877) list(2598.016 776.149) list(2594.848 772.981) list(2607.576 760.253) list(2610.744 763.421) list(2623.472 750.693) list(2620.304 747.525) list(2633.032 734.797) list(2636.200 737.965) list(2648.928 725.237) list(2645.760 722.069) list(2658.488 709.341) list(2661.656 712.509) list(2674.383 699.781) list(2671.216 696.613) list(2882.329 485.500) list(2997.329 485.500) list(3005.551 477.278) list(3005.551 470.000) list(3005.551 428.020) list(3019.016 414.555)) 5.400) "ETCH/BOTTOM" "PETN3_RECEPT")
  printf("DRC=%L\n" axlDRCUpdate(nil))
  axlSaveDesign(?noConfirm t)
  l2_dump("place17.txt"))
