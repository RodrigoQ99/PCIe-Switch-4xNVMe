;; move1.il -- generado por replace.py
procedure( mv_all()
  let((n)
    n = 0
    when(l2_mv("C741" 3211.000 520.000 270.0 t) n = n + 1)
    when(l2_mv("C742" 3172.000 520.000 270.0 t) n = n + 1)
    when(l2_mv("C751" 4156.000 520.000 270.0 t) n = n + 1)
    when(l2_mv("C752" 4117.000 520.000 270.0 t) n = n + 1)
    when(l2_mv("C761" 5101.000 520.000 270.0 t) n = n + 1)
    when(l2_mv("C762" 5062.000 520.000 270.0 t) n = n + 1)
    when(l2_mv("C771" 6046.000 520.000 270.0 t) n = n + 1)
    when(l2_mv("C772" 6007.000 520.000 270.0 t) n = n + 1)
    when(l2_mv("C99" 1725.000 1050.000 0.0 nil) n = n + 1)
    when(l2_mv("Q1" 2785.000 1325.000 0.0 nil) n = n + 1)
    when(l2_mv("Q2" 1585.000 490.000 0.0 nil) n = n + 1)
    when(l2_mv("R159" 3093.000 520.000 90.0 t) n = n + 1)
    when(l2_mv("R160" 3132.000 520.000 90.0 t) n = n + 1)
    when(l2_mv("R51" 2940.000 1195.000 0.0 nil) n = n + 1)
    when(l2_mv("R55" 2755.000 1805.000 0.0 nil) n = n + 1)
    when(l2_mv("R79" 3045.000 905.000 0.0 nil) n = n + 1)
    when(l2_mv("R88" 5967.000 520.000 90.0 t) n = n + 1)
    when(l2_mv("R89" 5928.000 520.000 90.0 t) n = n + 1)
    when(l2_mv("R90" 4983.000 520.000 90.0 t) n = n + 1)
    when(l2_mv("R91" 5022.000 520.000 90.0 t) n = n + 1)
    when(l2_mv("R92" 4038.000 520.000 90.0 t) n = n + 1)
    when(l2_mv("R93" 4077.000 520.000 90.0 t) n = n + 1)
    when(l2_mv("RD15" 2920.000 1145.000 0.0 nil) n = n + 1)
    when(l2_mv("RD85" 1740.000 710.000 0.0 nil) n = n + 1)
    when(l2_mv("RP10" 1810.000 885.000 0.0 nil) n = n + 1)
    when(l2_mv("RP11" 3055.000 1040.000 0.0 nil) n = n + 1)
    printf("movidas %d\n" n) n))

procedure( mv_go()
  mv_all()
  axlSaveDesign(?noConfirm t)
  printf("DRC=%L\n" axlDRCUpdate(nil))
  axlSaveDesign(?noConfirm t)
  l2_dump("place8.txt"))
