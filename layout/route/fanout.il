;; fanout.il -- generado por evb_fanout.py (fanout del BGA copiado del EVB, dy = -600)
procedure( fo_all()
  let((nv nc)
    nv = 0 nc = 0
    when(axlDBCreateVia("VIA10_20-FBD" list(2573.551 1837.700) "GND") nv = nv + 1)
    when(axlDBCreatePath(axlPathStart(list(list(2603.551 1832.389) list(2578.862 1832.389)) 12.000) "ETCH/BOTTOM" "GND") nc = nc + 1)
    when(axlDBCreatePath(axlPathStart(list(list(2578.862 1832.389) list(2573.551 1837.700)) 12.000) "ETCH/BOTTOM" "GND") nc = nc + 1)
    when(axlDBCreateVia("VIA10_20-FBD" list(2401.976 1686.086) "GND") nv = nv + 1)
    when(axlDBCreatePath(axlPathStart(list(list(2382.291 1666.401) list(2401.976 1686.086)) 12.000) "ETCH/TOP" "GND") nc = nc + 1)
    when(axlDBCreateVia("VIA10_20-FBD" list(2401.976 1725.457) "GND") nv = nv + 1)
    when(axlDBCreatePath(axlPathStart(list(list(2382.291 1705.772) list(2401.976 1725.457)) 12.000) "ETCH/TOP" "GND") nc = nc + 1)
    when(axlDBCreatePath(axlPathStart(list(list(2408.862 1762.700) list(2408.862 1732.343)) 12.000) "ETCH/BOTTOM" "GND") nc = nc + 1)
    when(axlDBCreatePath(axlPathStart(list(list(2408.862 1732.343) list(2401.976 1725.457)) 12.000) "ETCH/BOTTOM" "GND") nc = nc + 1)
    when(axlDBCreateVia("VIA10_20-FBD" list(2520.086 1725.457) "GND") nv = nv + 1)
    when(axlDBCreatePath(axlPathStart(list(list(2500.401 1705.772) list(2520.086 1725.457)) 12.000) "ETCH/TOP" "GND") nc = nc + 1)
    when(axlDBCreateVia("VIA10_20-FBD" list(2520.086 1489.236) "GND") nv = nv + 1)
    when(axlDBCreatePath(axlPathStart(list(list(2500.401 1469.551) list(2520.086 1489.236)) 12.000) "ETCH/TOP" "GND") nc = nc + 1)
    when(axlDBCreateVia("VIA10_20-FBD" list(2401.976 1489.236) "GND") nv = nv + 1)
    when(axlDBCreatePath(axlPathStart(list(list(2382.291 1469.551) list(2401.976 1489.236)) 12.000) "ETCH/TOP" "GND") nc = nc + 1)
    when(axlDBCreatePath(axlPathStart(list(list(2382.271 1470.180) list(2382.920 1470.180)) 12.000) "ETCH/BOTTOM" "GND") nc = nc + 1)
    when(axlDBCreatePath(axlPathStart(list(list(2382.920 1470.180) list(2401.976 1489.236)) 12.000) "ETCH/BOTTOM" "GND") nc = nc + 1)
    when(axlDBCreatePath(axlPathStart(list(list(2500.401 1587.661) list(2520.086 1607.346)) 12.000) "ETCH/TOP" "GND") nc = nc + 1)
    when(axlDBCreateVia("VIA10_20-FBD" list(2520.086 1607.346) "GND") nv = nv + 1)
    when(axlDBCreateVia("VIA10_20-FBD" list(2401.976 1567.976) "GND") nv = nv + 1)
    when(axlDBCreatePath(axlPathStart(list(list(2382.291 1548.291) list(2401.976 1567.976)) 12.000) "ETCH/TOP" "GND") nc = nc + 1)
    when(axlDBCreatePath(axlPathStart(list(list(2382.951 1587.580) list(2382.951 1587.001)) 12.000) "ETCH/BOTTOM" "GND") nc = nc + 1)
    when(axlDBCreatePath(axlPathStart(list(list(2382.951 1587.001) list(2401.976 1567.976)) 12.000) "ETCH/BOTTOM" "GND") nc = nc + 1)
    when(axlDBCreateVia("VIA10_20-FBD" list(2401.976 1607.346) "GND") nv = nv + 1)
    when(axlDBCreatePath(axlPathStart(list(list(2382.291 1587.661) list(2401.976 1607.346)) 12.000) "ETCH/TOP" "GND") nc = nc + 1)
    when(axlDBCreateVia("VIA10_20-FBD" list(2244.496 1528.606) "GND") nv = nv + 1)
    when(axlDBCreatePath(axlPathStart(list(list(2264.181 1508.921) list(2244.496 1528.606)) 12.000) "ETCH/TOP" "GND") nc = nc + 1)
    when(axlDBCreatePath(axlPathStart(list(list(2263.511 1508.860) list(2263.511 1509.591)) 12.000) "ETCH/BOTTOM" "GND") nc = nc + 1)
    when(axlDBCreatePath(axlPathStart(list(list(2263.511 1509.591) list(2244.496 1528.606)) 12.000) "ETCH/BOTTOM" "GND") nc = nc + 1)
    when(axlDBCreatePath(axlPathStart(list(list(2264.871 1548.220) list(2264.110 1548.220)) 12.000) "ETCH/BOTTOM" "GND") nc = nc + 1)
    when(axlDBCreatePath(axlPathStart(list(list(2264.110 1548.220) list(2244.496 1528.606)) 12.000) "ETCH/BOTTOM" "GND") nc = nc + 1)
    when(axlDBCreateVia("VIA10_20-FBD" list(2323.236 1489.236) "GND") nv = nv + 1)
    when(axlDBCreatePath(axlPathStart(list(list(2303.551 1469.551) list(2323.236 1489.236)) 12.000) "ETCH/TOP" "GND") nc = nc + 1)
    when(axlDBCreatePath(axlPathStart(list(list(2304.231 1469.500) list(2304.231 1470.231)) 12.000) "ETCH/BOTTOM" "GND") nc = nc + 1)
    when(axlDBCreatePath(axlPathStart(list(list(2304.231 1470.231) list(2323.236 1489.236)) 12.000) "ETCH/BOTTOM" "GND") nc = nc + 1)
    when(axlDBCreateVia("VIA10_20-FBD" list(2362.606 1528.606) "GND") nv = nv + 1)
    when(axlDBCreatePath(axlPathStart(list(list(2342.921 1508.921) list(2362.606 1528.606)) 12.000) "ETCH/TOP" "GND") nc = nc + 1)
    when(axlDBCreatePath(axlPathStart(list(list(2342.231 1508.860) list(2342.860 1508.860)) 12.000) "ETCH/BOTTOM" "GND") nc = nc + 1)
    when(axlDBCreatePath(axlPathStart(list(list(2342.860 1508.860) list(2362.606 1528.606)) 12.000) "ETCH/BOTTOM" "GND") nc = nc + 1)
    when(axlDBCreatePath(axlPathStart(list(list(2343.591 1548.220) list(2343.591 1547.621)) 12.000) "ETCH/BOTTOM" "GND") nc = nc + 1)
    when(axlDBCreatePath(axlPathStart(list(list(2343.591 1547.621) list(2362.606 1528.606)) 12.000) "ETCH/BOTTOM" "GND") nc = nc + 1)
    when(axlDBCreateVia("VIA10_20-FBD" list(2205.126 1489.236) "GND") nv = nv + 1)
    when(axlDBCreatePath(axlPathStart(list(list(2224.811 1469.551) list(2205.126 1489.236)) 12.000) "ETCH/TOP" "GND") nc = nc + 1)
    when(axlDBCreatePath(axlPathStart(list(list(2225.511 1469.500) list(2224.862 1469.500)) 12.000) "ETCH/BOTTOM" "GND") nc = nc + 1)
    when(axlDBCreatePath(axlPathStart(list(list(2224.862 1469.500) list(2205.126 1489.236)) 12.000) "ETCH/BOTTOM" "GND") nc = nc + 1)
    when(axlDBCreateVia("VIA10_20-FBD" list(2165.756 1528.606) "GND") nv = nv + 1)
    when(axlDBCreatePath(axlPathStart(list(list(2185.441 1508.921) list(2165.756 1528.606)) 12.000) "ETCH/TOP" "GND") nc = nc + 1)
    when(axlDBCreatePath(axlPathStart(list(list(2185.471 1508.180) list(2185.471 1508.891)) 12.000) "ETCH/BOTTOM" "GND") nc = nc + 1)
    when(axlDBCreatePath(axlPathStart(list(list(2185.471 1508.891) list(2165.756 1528.606)) 12.000) "ETCH/BOTTOM" "GND") nc = nc + 1)
    when(axlDBCreatePath(axlPathStart(list(list(2186.151 1548.220) list(2185.370 1548.220)) 12.000) "ETCH/BOTTOM" "GND") nc = nc + 1)
    when(axlDBCreatePath(axlPathStart(list(list(2185.370 1548.220) list(2165.756 1528.606)) 12.000) "ETCH/BOTTOM" "GND") nc = nc + 1)
    when(axlDBCreatePath(axlPathStart(list(list(2146.111 1508.180) list(2146.111 1508.961)) 12.000) "ETCH/BOTTOM" "GND") nc = nc + 1)
    when(axlDBCreatePath(axlPathStart(list(list(2146.111 1508.961) list(2165.756 1528.606)) 12.000) "ETCH/BOTTOM" "GND") nc = nc + 1)
    when(axlDBCreatePath(axlPathStart(list(list(2628.551 1337.700) list(2633.551 1337.700)) 12.000) "ETCH/BOTTOM" "GND") nc = nc + 1)
    when(axlDBCreatePath(axlPathStart(list(list(2633.551 1337.700) list(2638.862 1343.011)) 12.000) "ETCH/BOTTOM" "GND") nc = nc + 1)
    when(axlDBCreatePath(axlPathStart(list(list(2638.862 1343.011) list(2658.551 1343.011)) 12.000) "ETCH/BOTTOM" "GND") nc = nc + 1)
    when(axlDBCreateVia("VIA10_20-FBD" list(2628.551 1337.700) "GND") nv = nv + 1)
    when(axlDBCreateVia("VIA10_20-FBD" list(2568.551 1346.700) "GND") nv = nv + 1)
    when(axlDBCreatePath(axlPathStart(list(list(2598.551 1343.011) list(2572.240 1343.011)) 12.000) "ETCH/BOTTOM" "GND") nc = nc + 1)
    when(axlDBCreatePath(axlPathStart(list(list(2572.240 1343.011) list(2568.551 1346.700)) 12.000) "ETCH/BOTTOM" "GND") nc = nc + 1)
    when(axlDBCreateVia("VIA10_20-FBD" list(2520.066 1331.776) "GND") nv = nv + 1)
    when(axlDBCreatePath(axlPathStart(list(list(2500.401 1351.441) list(2520.066 1331.776)) 12.000) "ETCH/TOP" "GND") nc = nc + 1)
    when(axlDBCreateVia("VIA10_20-FBD" list(2363.276 1410.455) "GND") nv = nv + 1)
    when(axlDBCreateVia("VIA10_20-FBD" list(2401.976 1371.126) "GND") nv = nv + 1)
    when(axlDBCreatePath(axlPathStart(list(list(2382.291 1390.811) list(2401.976 1371.126)) 12.000) "ETCH/TOP" "GND") nc = nc + 1)
    when(axlDBCreatePath(axlPathStart(list(list(2343.591 1430.140) list(2363.276 1410.455)) 12.000) "ETCH/BOTTOM" "GND") nc = nc + 1)
    when(axlDBCreatePath(axlPathStart(list(list(2421.631 1390.100) list(2420.950 1390.100)) 12.000) "ETCH/BOTTOM" "GND") nc = nc + 1)
    when(axlDBCreatePath(axlPathStart(list(list(2420.950 1390.100) list(2401.976 1371.126)) 12.000) "ETCH/BOTTOM" "GND") nc = nc + 1)
    when(axlDBCreateVia("VIA10_20-FBD" list(2362.591 1371.100) "GND") nv = nv + 1)
    when(axlDBCreatePath(axlPathStart(list(list(2343.591 1351.420) list(2343.591 1352.100)) 12.000) "ETCH/BOTTOM" "GND") nc = nc + 1)
    when(axlDBCreatePath(axlPathStart(list(list(2343.591 1352.100) list(2362.591 1371.100)) 12.000) "ETCH/BOTTOM" "GND") nc = nc + 1)
    when(axlDBCreatePath(axlPathStart(list(list(2382.291 1390.811) list(2382.291 1390.800)) 12.000) "ETCH/TOP" "GND") nc = nc + 1)
    when(axlDBCreatePath(axlPathStart(list(list(2382.291 1390.800) list(2362.591 1371.100)) 12.000) "ETCH/TOP" "GND") nc = nc + 1)
    when(axlDBCreatePath(axlPathStart(list(list(2382.291 1390.811) list(2382.291 1391.440)) 12.000) "ETCH/TOP" "GND") nc = nc + 1)
    when(axlDBCreatePath(axlPathStart(list(list(2382.291 1391.440) list(2363.276 1410.455)) 12.000) "ETCH/TOP" "GND") nc = nc + 1)
    when(axlDBCreateVia("VIA10_20-FBD" list(2323.216 1410.476) "GND") nv = nv + 1)
    when(axlDBCreatePath(axlPathStart(list(list(2342.921 1430.181) list(2323.216 1410.476)) 12.000) "ETCH/TOP" "GND") nc = nc + 1)
    when(axlDBCreatePath(axlPathStart(list(list(2302.871 1430.140) list(2303.552 1430.140)) 12.000) "ETCH/BOTTOM" "GND") nc = nc + 1)
    when(axlDBCreatePath(axlPathStart(list(list(2303.552 1430.140) list(2323.216 1410.476)) 12.000) "ETCH/BOTTOM" "GND") nc = nc + 1)
    when(axlDBCreateVia("VIA10_20-FBD" list(2205.126 1371.126) "GND") nv = nv + 1)
    when(axlDBCreatePath(axlPathStart(list(list(2224.811 1390.811) list(2205.126 1371.126)) 12.000) "ETCH/TOP" "GND") nc = nc + 1)
    when(axlDBCreatePath(axlPathStart(list(list(2186.151 1390.780) list(2186.151 1390.101)) 12.000) "ETCH/BOTTOM" "GND") nc = nc + 1)
    when(axlDBCreatePath(axlPathStart(list(list(2186.151 1390.101) list(2205.126 1371.126)) 12.000) "ETCH/BOTTOM" "GND") nc = nc + 1)
    when(axlDBCreatePath(axlPathStart(list(list(2224.831 1350.740) list(2224.831 1351.421)) 12.000) "ETCH/BOTTOM" "GND") nc = nc + 1)
    when(axlDBCreatePath(axlPathStart(list(list(2224.831 1351.421) list(2205.126 1371.126)) 12.000) "ETCH/BOTTOM" "GND") nc = nc + 1)
    when(axlDBCreateVia("VIA10_20-FBD" list(2244.496 1410.496) "GND") nv = nv + 1)
    when(axlDBCreatePath(axlPathStart(list(list(2264.181 1430.181) list(2244.496 1410.496)) 12.000) "ETCH/TOP" "GND") nc = nc + 1)
    when(axlDBCreatePath(axlPathStart(list(list(2224.151 1430.140) list(2224.852 1430.140)) 12.000) "ETCH/BOTTOM" "GND") nc = nc + 1)
    when(axlDBCreatePath(axlPathStart(list(list(2224.852 1430.140) list(2244.496 1410.496)) 12.000) "ETCH/BOTTOM" "GND") nc = nc + 1)
    when(axlDBCreateVia("VIA10_20-FBD" list(2283.856 1371.116) "GND") nv = nv + 1)
    when(axlDBCreatePath(axlPathStart(list(list(2303.551 1390.811) list(2283.856 1371.116)) 12.000) "ETCH/TOP" "GND") nc = nc + 1)
    when(axlDBCreatePath(axlPathStart(list(list(2264.871 1390.780) list(2264.871 1390.101)) 12.000) "ETCH/BOTTOM" "GND") nc = nc + 1)
    when(axlDBCreatePath(axlPathStart(list(list(2264.871 1390.101) list(2283.856 1371.116)) 12.000) "ETCH/BOTTOM" "GND") nc = nc + 1)
    when(axlDBCreatePath(axlPathStart(list(list(2146.791 1351.420) list(2146.092 1351.420)) 12.000) "ETCH/BOTTOM" "GND") nc = nc + 1)
    when(axlDBCreatePath(axlPathStart(list(list(2146.092 1351.420) list(2126.422 1371.090)) 12.000) "ETCH/BOTTOM" "GND") nc = nc + 1)
    when(axlDBCreateVia("VIA10_20-FBD" list(2126.422 1371.090) "GND") nv = nv + 1)
    when(axlDBCreatePath(axlPathStart(list(list(2146.071 1351.441) list(2126.422 1371.090)) 12.000) "ETCH/TOP" "GND") nc = nc + 1)
    when(axlDBCreatePath(axlPathStart(list(list(2106.751 1390.100) list(2107.412 1390.100)) 12.000) "ETCH/BOTTOM" "GND") nc = nc + 1)
    when(axlDBCreatePath(axlPathStart(list(list(2107.412 1390.100) list(2126.422 1371.090)) 12.000) "ETCH/BOTTOM" "GND") nc = nc + 1)
    when(axlDBCreateVia("VIA10_20-FBD" list(2165.756 1410.496) "GND") nv = nv + 1)
    when(axlDBCreatePath(axlPathStart(list(list(2185.441 1430.181) list(2165.756 1410.496)) 12.000) "ETCH/TOP" "GND") nc = nc + 1)
    when(axlDBCreatePath(axlPathStart(list(list(2146.111 1429.460) list(2146.792 1429.460)) 12.000) "ETCH/BOTTOM" "GND") nc = nc + 1)
    when(axlDBCreatePath(axlPathStart(list(list(2146.792 1429.460) list(2165.756 1410.496)) 12.000) "ETCH/BOTTOM" "GND") nc = nc + 1)
    when(axlDBCreatePath(axlPathStart(list(list(2067.331 1390.811) list(2047.696 1410.446)) 12.000) "ETCH/TOP" "GND") nc = nc + 1)
    when(axlDBCreateVia("VIA10_20-FBD" list(2047.696 1410.446) "GND") nv = nv + 1)
    when(axlDBCreatePath(axlPathStart(list(list(2067.331 1508.921) list(2047.646 1528.606)) 12.000) "ETCH/TOP" "GND") nc = nc + 1)
    when(axlDBCreateVia("VIA10_20-FBD" list(2047.646 1528.606) "GND") nv = nv + 1)
    when(axlDBCreateVia("VIA10_20-FBD" list(2520.086 1213.646) "GND") nv = nv + 1)
    when(axlDBCreatePath(axlPathStart(list(list(2500.401 1233.331) list(2520.086 1213.646)) 12.000) "ETCH/TOP" "GND") nc = nc + 1)
    when(axlDBCreatePath(axlPathStart(list(list(2342.921 1272.701) list(2362.596 1253.026)) 12.000) "ETCH/TOP" "GND") nc = nc + 1)
    when(axlDBCreateVia("VIA10_20-FBD" list(2362.596 1253.026) "GND") nv = nv + 1)
    when(axlDBCreatePath(axlPathStart(list(list(2303.551 1272.701) list(2283.870 1253.020)) 12.000) "ETCH/TOP" "GND") nc = nc + 1)
    when(axlDBCreateVia("VIA10_20-FBD" list(2283.870 1253.020) "GND") nv = nv + 1)
    when(axlDBCreatePath(axlPathStart(list(list(2264.181 1272.701) list(2283.866 1292.386)) 12.000) "ETCH/TOP" "GND") nc = nc + 1)
    when(axlDBCreateVia("VIA10_20-FBD" list(2283.866 1292.386) "GND") nv = nv + 1)
    when(axlDBCreatePath(axlPathStart(list(list(2264.181 1627.031) list(2283.820 1646.670)) 12.000) "ETCH/TOP" "GND") nc = nc + 1)
    when(axlDBCreateVia("VIA10_20-FBD" list(2283.820 1646.670) "GND") nv = nv + 1)
    when(axlDBCreatePath(axlPathStart(list(list(2303.551 1627.031) list(2283.826 1607.306)) 12.000) "ETCH/TOP" "GND") nc = nc + 1)
    when(axlDBCreateVia("VIA10_20-FBD" list(2283.826 1607.306) "GND") nv = nv + 1)
    when(axlDBCreatePath(axlPathStart(list(list(2106.751 1548.900) list(2107.310 1548.900)) 12.000) "ETCH/BOTTOM" "GND") nc = nc + 1)
    when(axlDBCreatePath(axlPathStart(list(list(2107.310 1548.900) list(2126.386 1567.976)) 12.000) "ETCH/BOTTOM" "GND") nc = nc + 1)
    when(axlDBCreatePath(axlPathStart(list(list(2146.071 1548.291) list(2126.386 1567.976)) 12.000) "ETCH/TOP" "GND") nc = nc + 1)
    when(axlDBCreateVia("VIA10_20-FBD" list(2126.386 1567.976) "GND") nv = nv + 1)
    when(axlDBCreatePath(axlPathStart(list(list(2382.951 1626.940) list(2382.382 1626.940)) 12.000) "ETCH/BOTTOM" "GND") nc = nc + 1)
    when(axlDBCreatePath(axlPathStart(list(list(2382.382 1626.940) list(2362.606 1646.716)) 12.000) "ETCH/BOTTOM" "GND") nc = nc + 1)
    when(axlDBCreatePath(axlPathStart(list(list(2342.921 1627.031) list(2362.606 1646.716)) 12.000) "ETCH/TOP" "GND") nc = nc + 1)
    when(axlDBCreateVia("VIA10_20-FBD" list(2362.606 1646.716) "GND") nv = nv + 1)
    when(axlDBCreatePath(axlPathStart(list(list(2068.071 1626.940) list(2067.422 1626.940)) 12.000) "ETCH/BOTTOM" "GND") nc = nc + 1)
    when(axlDBCreatePath(axlPathStart(list(list(2067.422 1626.940) list(2047.646 1646.716)) 12.000) "ETCH/BOTTOM" "GND") nc = nc + 1)
    when(axlDBCreatePath(axlPathStart(list(list(2067.331 1627.031) list(2047.646 1646.716)) 12.000) "ETCH/TOP" "GND") nc = nc + 1)
    when(axlDBCreateVia("VIA10_20-FBD" list(2047.646 1646.716) "GND") nv = nv + 1)
    when(axlDBCreatePath(axlPathStart(list(list(2146.071 1233.331) list(2126.416 1213.676)) 12.000) "ETCH/TOP" "GND") nc = nc + 1)
    when(axlDBCreateVia("VIA10_20-FBD" list(2126.416 1213.676) "GND") nv = nv + 1)
    when(axlDBCreatePath(axlPathStart(list(list(2146.071 1193.960) list(2126.421 1174.310)) 12.000) "ETCH/TOP" "GND") nc = nc + 1)
    when(axlDBCreateVia("VIA10_20-FBD" list(2126.421 1174.310) "GND") nv = nv + 1)
    when(axlDBCreatePath(axlPathStart(list(list(2146.071 1705.772) list(2146.071 1732.700)) 12.000) "ETCH/TOP" "GND") nc = nc + 1)
    when(axlDBCreatePath(axlPathStart(list(list(2146.071 1666.401) list(2146.071 1705.772)) 12.000) "ETCH/TOP" "GND") nc = nc + 1)
    when(axlDBCreatePath(axlPathStart(list(list(2146.071 1666.401) list(2165.756 1646.716)) 12.000) "ETCH/TOP" "GND") nc = nc + 1)
    when(axlDBCreatePath(axlPathStart(list(list(2185.441 1627.031) list(2165.756 1646.716)) 12.000) "ETCH/TOP" "GND") nc = nc + 1)
    when(axlDBCreateVia("VIA10_20-FBD" list(2146.071 1732.700) "GND") nv = nv + 1)
    when(axlDBCreateVia("VIA10_20-FBD" list(2165.756 1646.716) "GND") nv = nv + 1)
    when(axlDBCreatePath(axlPathStart(list(list(2224.811 1627.031) list(2244.456 1646.676)) 12.000) "ETCH/TOP" "GND") nc = nc + 1)
    when(axlDBCreatePath(axlPathStart(list(list(2244.456 1646.676) list(2244.456 1645.995)) 12.000) "ETCH/BOTTOM" "GND") nc = nc + 1)
    when(axlDBCreatePath(axlPathStart(list(list(2244.456 1645.995) list(2244.456 1645.885)) 12.000) "ETCH/BOTTOM" "GND") nc = nc + 1)
    when(axlDBCreatePath(axlPathStart(list(list(2244.456 1645.885) list(2224.831 1626.260)) 12.000) "ETCH/BOTTOM" "GND") nc = nc + 1)
    when(axlDBCreatePath(axlPathStart(list(list(2264.191 1626.260) list(2244.456 1645.995)) 12.000) "ETCH/BOTTOM" "GND") nc = nc + 1)
    when(axlDBCreateVia("VIA10_20-FBD" list(2244.456 1646.676) "GND") nv = nv + 1)
    when(axlDBCreatePath(axlPathStart(list(list(2382.951 1272.700) list(2382.951 1273.381)) 12.000) "ETCH/BOTTOM" "GND") nc = nc + 1)
    when(axlDBCreatePath(axlPathStart(list(list(2382.951 1273.381) list(2401.966 1292.396)) 12.000) "ETCH/BOTTOM" "GND") nc = nc + 1)
    when(axlDBCreatePath(axlPathStart(list(list(2382.951 1312.060) list(2401.966 1293.045)) 12.000) "ETCH/BOTTOM" "GND") nc = nc + 1)
    when(axlDBCreatePath(axlPathStart(list(list(2401.966 1293.045) list(2401.966 1292.396)) 12.000) "ETCH/BOTTOM" "GND") nc = nc + 1)
    when(axlDBCreatePath(axlPathStart(list(list(2382.291 1312.071) list(2401.966 1292.396)) 12.000) "ETCH/TOP" "GND") nc = nc + 1)
    when(axlDBCreateVia("VIA10_20-FBD" list(2401.966 1292.396) "GND") nv = nv + 1)
    when(axlDBCreatePath(axlPathStart(list(list(2224.811 1272.701) list(2244.502 1253.010)) 12.000) "ETCH/TOP" "GND") nc = nc + 1)
    when(axlDBCreateVia("VIA10_20-FBD" list(2244.502 1253.010) "GND") nv = nv + 1)
    when(axlDBCreatePath(axlPathStart(list(list(2244.502 1193.980) list(2224.831 1213.651)) 12.000) "ETCH/BOTTOM" "GND") nc = nc + 1)
    when(axlDBCreatePath(axlPathStart(list(list(2224.831 1213.651) list(2224.831 1234.020)) 12.000) "ETCH/BOTTOM" "GND") nc = nc + 1)
    when(axlDBCreatePath(axlPathStart(list(list(2224.831 1234.020) list(2224.122 1234.020)) 12.000) "ETCH/BOTTOM" "GND") nc = nc + 1)
    when(axlDBCreatePath(axlPathStart(list(list(2224.122 1234.020) list(2205.136 1253.006)) 12.000) "ETCH/BOTTOM" "GND") nc = nc + 1)
    when(axlDBCreatePath(axlPathStart(list(list(2185.441 1272.701) list(2205.136 1253.006)) 12.000) "ETCH/TOP" "GND") nc = nc + 1)
    when(axlDBCreateVia("VIA10_20-FBD" list(2205.136 1253.006) "GND") nv = nv + 1)
    when(axlDBCreatePath(axlPathStart(list(list(2067.331 1272.701) list(2087.040 1292.410)) 12.000) "ETCH/TOP" "GND") nc = nc + 1)
    when(axlDBCreatePath(axlPathStart(list(list(2068.071 1312.060) list(2068.071 1311.379)) 12.000) "ETCH/BOTTOM" "GND") nc = nc + 1)
    when(axlDBCreatePath(axlPathStart(list(list(2068.071 1311.379) list(2087.040 1292.410)) 12.000) "ETCH/BOTTOM" "GND") nc = nc + 1)
    when(axlDBCreateVia("VIA10_20-FBD" list(2087.040 1292.410) "GND") nv = nv + 1)
    when(axlDBCreatePath(axlPathStart(list(list(2163.551 1823.011) list(2191.220 1823.011)) 12.000) "ETCH/BOTTOM" "GND") nc = nc + 1)
    when(axlDBCreatePath(axlPathStart(list(list(2191.220 1823.011) list(2201.794 1833.585)) 12.000) "ETCH/BOTTOM" "GND") nc = nc + 1)
    when(axlDBCreateVia("VIA10_20-FBD" list(2201.794 1833.585) "GND") nv = nv + 1)
    when(axlDBCreatePath(axlPathStart(list(list(2421.631 1193.300) list(2421.631 1193.991)) 12.000) "ETCH/BOTTOM" "GND") nc = nc + 1)
    when(axlDBCreatePath(axlPathStart(list(list(2421.631 1193.991) list(2401.956 1213.666)) 12.000) "ETCH/BOTTOM" "GND") nc = nc + 1)
    when(axlDBCreatePath(axlPathStart(list(list(2382.271 1193.300) list(2382.271 1193.981)) 12.000) "ETCH/BOTTOM" "GND") nc = nc + 1)
    when(axlDBCreatePath(axlPathStart(list(list(2382.271 1193.981) list(2401.956 1213.666)) 12.000) "ETCH/BOTTOM" "GND") nc = nc + 1)
    when(axlDBCreatePath(axlPathStart(list(list(2382.291 1233.331) list(2401.956 1213.666)) 12.000) "ETCH/TOP" "GND") nc = nc + 1)
    when(axlDBCreateVia("VIA10_20-FBD" list(2401.956 1213.666) "GND") nv = nv + 1)
    when(axlDBCreatePath(axlPathStart(list(list(1864.049 1623.202) list(1899.551 1587.700)) 5.000) "ETCH/BOTTOM" "EEDI") nc = nc + 1)
    when(axlDBCreatePath(axlPathStart(list(list(1899.551 1587.700) list(2067.292 1587.700)) 5.000) "ETCH/BOTTOM" "EEDI") nc = nc + 1)
    when(axlDBCreatePath(axlPathStart(list(list(2067.292 1587.700) list(2087.016 1567.976)) 5.000) "ETCH/BOTTOM" "EEDI") nc = nc + 1)
    when(axlDBCreateVia("VIA10_20-FBD" list(2087.016 1567.976) "EEDI") nv = nv + 1)
    when(axlDBCreatePath(axlPathStart(list(list(2106.701 1548.291) list(2087.016 1567.976)) 5.000) "ETCH/TOP" "EEDI") nc = nc + 1)
    when(axlDBCreatePath(axlPathStart(list(list(1903.551 1527.700) list(2009.181 1527.700)) 5.000) "ETCH/TOP" "EEDO") nc = nc + 1)
    when(axlDBCreatePath(axlPathStart(list(list(2009.181 1527.700) list(2027.960 1508.921)) 5.000) "ETCH/TOP" "EEDO") nc = nc + 1)
    when(axlDBCreateVia("VIA10_20-FBD" list(1903.551 1527.700) "EEDO") nv = nv + 1)
    when(axlDBCreatePath(axlPathStart(list(list(2028.551 1442.700) list(2038.551 1452.700)) 5.000) "ETCH/BOTTOM" "TMS") nc = nc + 1)
    when(axlDBCreatePath(axlPathStart(list(list(2038.551 1452.700) list(2050.480 1452.700)) 5.000) "ETCH/BOTTOM" "TMS") nc = nc + 1)
    when(axlDBCreatePath(axlPathStart(list(list(2050.480 1452.700) list(2087.016 1489.236)) 5.000) "ETCH/BOTTOM" "TMS") nc = nc + 1)
    when(axlDBCreateVia("VIA10_20-FBD" list(2087.016 1489.236) "TMS") nv = nv + 1)
    when(axlDBCreatePath(axlPathStart(list(list(2106.701 1469.551) list(2087.016 1489.236)) 5.000) "ETCH/TOP" "TMS") nc = nc + 1)
    when(axlDBCreateVia("VIA10_20-FBD" list(2126.386 1489.236) "TRST_L") nv = nv + 1)
    when(axlDBCreatePath(axlPathStart(list(list(2146.071 1469.551) list(2126.386 1489.236)) 5.000) "ETCH/TOP" "TRST_L") nc = nc + 1)
    when(axlDBCreatePath(axlPathStart(list(list(2033.551 1422.700) list(2078.551 1467.700)) 5.000) "ETCH/BOTTOM" "TRST_L") nc = nc + 1)
    when(axlDBCreatePath(axlPathStart(list(list(2078.551 1467.700) list(2104.850 1467.700)) 5.000) "ETCH/BOTTOM" "TRST_L") nc = nc + 1)
    when(axlDBCreatePath(axlPathStart(list(list(2104.850 1467.700) list(2126.386 1489.236)) 5.000) "ETCH/BOTTOM" "TRST_L") nc = nc + 1)
    when(axlDBCreateVia("VIA10_20-FBD" list(2283.830 1567.940) "SMBUS_EN_L") nv = nv + 1)
    when(axlDBCreatePath(axlPathStart(list(list(2264.181 1548.291) list(2283.830 1567.940)) 5.000) "ETCH/TOP" "SMBUS_EN_L") nc = nc + 1)
    when(axlDBCreatePath(axlPathStart(list(list(1860.551 1567.700) list(1959.142 1567.700)) 5.000) "ETCH/BOTTOM" "EECS_L") nc = nc + 1)
    when(axlDBCreatePath(axlPathStart(list(list(1959.142 1567.700) list(1978.551 1548.291)) 5.000) "ETCH/BOTTOM" "EECS_L") nc = nc + 1)
    when(axlDBCreateVia("VIA10_20-FBD" list(1978.551 1548.291) "EECS_L") nv = nv + 1)
    when(axlDBCreatePath(axlPathStart(list(list(2027.960 1548.291) list(1978.551 1548.291)) 5.000) "ETCH/TOP" "EECS_L") nc = nc + 1)
    when(axlDBCreatePath(axlPathStart(list(list(1913.751 1567.900) list(2047.722 1567.900)) 5.000) "ETCH/TOP" "EECK") nc = nc + 1)
    when(axlDBCreatePath(axlPathStart(list(list(2047.722 1567.900) list(2067.331 1548.291)) 5.000) "ETCH/TOP" "EECK") nc = nc + 1)
    when(axlDBCreatePath(axlPathStart(list(list(2342.921 1666.401) list(2364.551 1688.031)) 5.400) "ETCH/TOP" "PERP4_RECEPT") nc = nc + 1)
    when(axlDBCreatePath(axlPathStart(list(list(2342.921 1705.772) list(2353.551 1716.402)) 5.400) "ETCH/TOP" "PERN4_RECEPT") nc = nc + 1)
    when(axlDBCreatePath(axlPathStart(list(list(2273.551 1690.144) list(2304.551 1659.144)) 5.400) "ETCH/BOTTOM" "PETP5_RECEPT") nc = nc + 1)
    when(axlDBCreatePath(axlPathStart(list(list(2304.551 1659.144) list(2304.551 1586.574)) 5.400) "ETCH/BOTTOM" "PETP5_RECEPT") nc = nc + 1)
    when(axlDBCreatePath(axlPathStart(list(list(2304.551 1586.574) list(2323.225 1567.896)) 5.400) "ETCH/BOTTOM" "PETP5_RECEPT") nc = nc + 1)
    when(axlDBCreateVia("VIA10_20-FBD" list(2323.225 1567.896) "PETP5_RECEPT") nv = nv + 1)
    when(axlDBCreatePath(axlPathStart(list(list(2303.551 1548.291) list(2323.156 1567.896)) 5.000) "ETCH/TOP" "PETP5_RECEPT") nc = nc + 1)
    when(axlDBCreatePath(axlPathStart(list(list(2323.156 1567.896) list(2323.225 1567.896)) 5.000) "ETCH/TOP" "PETP5_RECEPT") nc = nc + 1)
    when(axlDBCreatePath(axlPathStart(list(list(2323.231 1607.260) list(2320.951 1607.260)) 5.400) "ETCH/BOTTOM" "PETN5_RECEPT") nc = nc + 1)
    when(axlDBCreatePath(axlPathStart(list(list(2320.951 1607.260) list(2315.551 1612.660)) 5.400) "ETCH/BOTTOM" "PETN5_RECEPT") nc = nc + 1)
    when(axlDBCreatePath(axlPathStart(list(list(2315.551 1612.660) list(2315.551 1672.700)) 5.400) "ETCH/BOTTOM" "PETN5_RECEPT") nc = nc + 1)
    when(axlDBCreatePath(axlPathStart(list(list(2315.551 1672.700) list(2305.551 1682.700)) 5.400) "ETCH/BOTTOM" "PETN5_RECEPT") nc = nc + 1)
    when(axlDBCreatePath(axlPathStart(list(list(2305.551 1682.700) list(2296.552 1682.700)) 5.400) "ETCH/BOTTOM" "PETN5_RECEPT") nc = nc + 1)
    when(axlDBCreatePath(axlPathStart(list(list(2296.552 1682.700) list(2284.551 1694.701)) 5.400) "ETCH/BOTTOM" "PETN5_RECEPT") nc = nc + 1)
    when(axlDBCreatePath(axlPathStart(list(list(2284.551 1694.701) list(2284.551 1726.657)) 5.400) "ETCH/BOTTOM" "PETN5_RECEPT") nc = nc + 1)
    when(axlDBCreatePath(axlPathStart(list(list(2284.551 1726.657) list(2293.551 1735.657)) 5.400) "ETCH/BOTTOM" "PETN5_RECEPT") nc = nc + 1)
    when(axlDBCreatePath(axlPathStart(list(list(2293.551 1735.657) list(2293.551 1748.257)) 5.400) "ETCH/BOTTOM" "PETN5_RECEPT") nc = nc + 1)
    when(axlDBCreatePath(axlPathStart(list(list(2293.551 1748.257) list(2284.551 1757.257)) 5.400) "ETCH/BOTTOM" "PETN5_RECEPT") nc = nc + 1)
    when(axlDBCreatePath(axlPathStart(list(list(2284.551 1757.257) list(2284.551 1769.857)) 5.400) "ETCH/BOTTOM" "PETN5_RECEPT") nc = nc + 1)
    when(axlDBCreatePath(axlPathStart(list(list(2284.551 1769.857) list(2293.551 1778.857)) 5.400) "ETCH/BOTTOM" "PETN5_RECEPT") nc = nc + 1)
    when(axlDBCreatePath(axlPathStart(list(list(2293.551 1778.857) list(2293.551 1791.457)) 5.400) "ETCH/BOTTOM" "PETN5_RECEPT") nc = nc + 1)
    when(axlDBCreatePath(axlPathStart(list(list(2293.551 1791.457) list(2284.551 1800.457)) 5.400) "ETCH/BOTTOM" "PETN5_RECEPT") nc = nc + 1)
    when(axlDBCreatePath(axlPathStart(list(list(2284.551 1800.457) list(2284.551 1813.057)) 5.400) "ETCH/BOTTOM" "PETN5_RECEPT") nc = nc + 1)
    when(axlDBCreatePath(axlPathStart(list(list(2284.551 1813.057) list(2293.551 1822.057)) 5.400) "ETCH/BOTTOM" "PETN5_RECEPT") nc = nc + 1)
    when(axlDBCreatePath(axlPathStart(list(list(2293.551 1822.057) list(2293.551 1834.657)) 5.400) "ETCH/BOTTOM" "PETN5_RECEPT") nc = nc + 1)
    when(axlDBCreatePath(axlPathStart(list(list(2293.551 1834.657) list(2284.551 1843.657)) 5.400) "ETCH/BOTTOM" "PETN5_RECEPT") nc = nc + 1)
    when(axlDBCreatePath(axlPathStart(list(list(2284.551 1843.657) list(2284.551 1856.257)) 5.400) "ETCH/BOTTOM" "PETN5_RECEPT") nc = nc + 1)
    when(axlDBCreatePath(axlPathStart(list(list(2284.551 1856.257) list(2293.551 1865.257)) 5.400) "ETCH/BOTTOM" "PETN5_RECEPT") nc = nc + 1)
    when(axlDBCreatePath(axlPathStart(list(list(2303.551 1587.661) list(2323.150 1607.260)) 5.000) "ETCH/TOP" "PETN5_RECEPT") nc = nc + 1)
    when(axlDBCreatePath(axlPathStart(list(list(2323.150 1607.260) list(2323.231 1607.260)) 5.000) "ETCH/TOP" "PETN5_RECEPT") nc = nc + 1)
    when(axlDBCreateVia("VIA10_20-FBD" list(2323.231 1607.260) "PETN5_RECEPT") nv = nv + 1)
    when(axlDBCreatePath(axlPathStart(list(list(2303.551 1666.401) list(2283.551 1686.401)) 5.400) "ETCH/TOP" "PERP5_RECEPT") nc = nc + 1)
    when(axlDBCreatePath(axlPathStart(list(list(2303.551 1705.772) list(2315.551 1705.772)) 5.400) "ETCH/TOP" "PERN5_RECEPT") nc = nc + 1)
    when(axlDBCreatePath(axlPathStart(list(list(2315.551 1705.772) list(2320.551 1710.772)) 5.400) "ETCH/TOP" "PERN5_RECEPT") nc = nc + 1)
    when(axlDBCreatePath(axlPathStart(list(list(2320.551 1710.772) list(2320.551 1725.700)) 5.400) "ETCH/TOP" "PERN5_RECEPT") nc = nc + 1)
    when(axlDBCreatePath(axlPathStart(list(list(2320.551 1725.700) list(2313.551 1732.700)) 5.400) "ETCH/TOP" "PERN5_RECEPT") nc = nc + 1)
    when(axlDBCreatePath(axlPathStart(list(list(2313.551 1732.700) list(2299.951 1732.700)) 5.400) "ETCH/TOP" "PERN5_RECEPT") nc = nc + 1)
    when(axlDBCreatePath(axlPathStart(list(list(2299.951 1732.700) list(2294.551 1738.100)) 5.400) "ETCH/TOP" "PERN5_RECEPT") nc = nc + 1)
    when(axlDBCreatePath(axlPathStart(list(list(2294.551 1738.100) list(2294.551 1748.986)) 5.400) "ETCH/TOP" "PERN5_RECEPT") nc = nc + 1)
    when(axlDBCreatePath(axlPathStart(list(list(2294.551 1748.986) list(2303.551 1757.986)) 5.400) "ETCH/TOP" "PERN5_RECEPT") nc = nc + 1)
    when(axlDBCreatePath(axlPathStart(list(list(2303.551 1757.986) list(2303.551 1770.586)) 5.400) "ETCH/TOP" "PERN5_RECEPT") nc = nc + 1)
    when(axlDBCreatePath(axlPathStart(list(list(2303.551 1770.586) list(2294.551 1779.586)) 5.400) "ETCH/TOP" "PERN5_RECEPT") nc = nc + 1)
    when(axlDBCreatePath(axlPathStart(list(list(2294.551 1779.586) list(2294.551 1792.186)) 5.400) "ETCH/TOP" "PERN5_RECEPT") nc = nc + 1)
    when(axlDBCreatePath(axlPathStart(list(list(2294.551 1792.186) list(2303.551 1801.186)) 5.400) "ETCH/TOP" "PERN5_RECEPT") nc = nc + 1)
    when(axlDBCreatePath(axlPathStart(list(list(2303.551 1801.186) list(2303.551 1813.786)) 5.400) "ETCH/TOP" "PERN5_RECEPT") nc = nc + 1)
    when(axlDBCreatePath(axlPathStart(list(list(2303.551 1813.786) list(2294.551 1822.786)) 5.400) "ETCH/TOP" "PERN5_RECEPT") nc = nc + 1)
    when(axlDBCreatePath(axlPathStart(list(list(2226.551 1807.257) list(2183.551 1764.257)) 5.400) "ETCH/BOTTOM" "PETP6_RECEPT") nc = nc + 1)
    when(axlDBCreatePath(axlPathStart(list(list(2183.551 1764.257) list(2183.551 1589.551)) 5.400) "ETCH/BOTTOM" "PETP6_RECEPT") nc = nc + 1)
    when(axlDBCreatePath(axlPathStart(list(list(2183.551 1589.551) list(2205.126 1567.976)) 5.400) "ETCH/BOTTOM" "PETP6_RECEPT") nc = nc + 1)
    when(axlDBCreateVia("VIA10_20-FBD" list(2205.126 1567.976) "PETP6_RECEPT") nv = nv + 1)
    when(axlDBCreatePath(axlPathStart(list(list(2224.811 1548.291) list(2205.126 1567.976)) 5.000) "ETCH/TOP" "PETP6_RECEPT") nc = nc + 1)
    when(axlDBCreatePath(axlPathStart(list(list(2237.551 1802.700) list(2227.822 1792.971)) 5.400) "ETCH/BOTTOM" "PETN6_RECEPT") nc = nc + 1)
    when(axlDBCreatePath(axlPathStart(list(list(2227.822 1792.971) list(2227.822 1777.971)) 5.400) "ETCH/BOTTOM" "PETN6_RECEPT") nc = nc + 1)
    when(axlDBCreatePath(axlPathStart(list(list(2227.822 1777.971) list(2220.048 1770.197)) 5.400) "ETCH/BOTTOM" "PETN6_RECEPT") nc = nc + 1)
    when(axlDBCreatePath(axlPathStart(list(list(2220.048 1770.197) list(2205.048 1770.197)) 5.400) "ETCH/BOTTOM" "PETN6_RECEPT") nc = nc + 1)
    when(axlDBCreatePath(axlPathStart(list(list(2205.048 1770.197) list(2194.551 1759.700)) 5.400) "ETCH/BOTTOM" "PETN6_RECEPT") nc = nc + 1)
    when(axlDBCreatePath(axlPathStart(list(list(2194.551 1759.700) list(2194.551 1746.288)) 5.400) "ETCH/BOTTOM" "PETN6_RECEPT") nc = nc + 1)
    when(axlDBCreatePath(axlPathStart(list(list(2194.551 1746.288) list(2204.551 1736.288)) 5.400) "ETCH/BOTTOM" "PETN6_RECEPT") nc = nc + 1)
    when(axlDBCreatePath(axlPathStart(list(list(2204.551 1736.288) list(2204.551 1724.688)) 5.400) "ETCH/BOTTOM" "PETN6_RECEPT") nc = nc + 1)
    when(axlDBCreatePath(axlPathStart(list(list(2204.551 1724.688) list(2194.551 1714.688)) 5.400) "ETCH/BOTTOM" "PETN6_RECEPT") nc = nc + 1)
    when(axlDBCreatePath(axlPathStart(list(list(2194.551 1714.688) list(2194.551 1703.088)) 5.400) "ETCH/BOTTOM" "PETN6_RECEPT") nc = nc + 1)
    when(axlDBCreatePath(axlPathStart(list(list(2194.551 1703.088) list(2204.551 1693.088)) 5.400) "ETCH/BOTTOM" "PETN6_RECEPT") nc = nc + 1)
    when(axlDBCreatePath(axlPathStart(list(list(2204.551 1693.088) list(2204.551 1681.488)) 5.400) "ETCH/BOTTOM" "PETN6_RECEPT") nc = nc + 1)
    when(axlDBCreatePath(axlPathStart(list(list(2204.551 1681.488) list(2194.551 1671.488)) 5.400) "ETCH/BOTTOM" "PETN6_RECEPT") nc = nc + 1)
    when(axlDBCreatePath(axlPathStart(list(list(2194.551 1671.488) list(2194.551 1661.787)) 5.400) "ETCH/BOTTOM" "PETN6_RECEPT") nc = nc + 1)
    when(axlDBCreatePath(axlPathStart(list(list(2194.551 1661.787) list(2202.551 1653.787)) 5.400) "ETCH/BOTTOM" "PETN6_RECEPT") nc = nc + 1)
    when(axlDBCreatePath(axlPathStart(list(list(2202.551 1653.787) list(2202.551 1640.187)) 5.400) "ETCH/BOTTOM" "PETN6_RECEPT") nc = nc + 1)
    when(axlDBCreatePath(axlPathStart(list(list(2202.551 1640.187) list(2194.551 1632.187)) 5.400) "ETCH/BOTTOM" "PETN6_RECEPT") nc = nc + 1)
    when(axlDBCreatePath(axlPathStart(list(list(2194.551 1632.187) list(2194.551 1617.921)) 5.400) "ETCH/BOTTOM" "PETN6_RECEPT") nc = nc + 1)
    when(axlDBCreatePath(axlPathStart(list(list(2194.551 1617.921) list(2205.126 1607.346)) 5.400) "ETCH/BOTTOM" "PETN6_RECEPT") nc = nc + 1)
    when(axlDBCreateVia("VIA10_20-FBD" list(2205.126 1607.346) "PETN6_RECEPT") nv = nv + 1)
    when(axlDBCreatePath(axlPathStart(list(list(2224.811 1587.661) list(2205.126 1607.346)) 5.000) "ETCH/TOP" "PETN6_RECEPT") nc = nc + 1)
    when(axlDBCreatePath(axlPathStart(list(list(2224.811 1666.401) list(2206.551 1684.661)) 5.400) "ETCH/TOP" "PERP6_RECEPT") nc = nc + 1)
    when(axlDBCreatePath(axlPathStart(list(list(2206.551 1684.661) list(2206.551 1779.700)) 5.400) "ETCH/TOP" "PERP6_RECEPT") nc = nc + 1)
    when(axlDBCreatePath(axlPathStart(list(list(2224.811 1705.772) list(2217.551 1713.032)) 5.400) "ETCH/TOP" "PERN6_RECEPT") nc = nc + 1)
    when(axlDBCreatePath(axlPathStart(list(list(2217.551 1713.032) list(2217.551 1727.767)) 5.400) "ETCH/TOP" "PERN6_RECEPT") nc = nc + 1)
    when(axlDBCreatePath(axlPathStart(list(list(2217.551 1727.767) list(2226.551 1736.767)) 5.400) "ETCH/TOP" "PERN6_RECEPT") nc = nc + 1)
    when(axlDBCreatePath(axlPathStart(list(list(2226.551 1736.767) list(2226.551 1749.367)) 5.400) "ETCH/TOP" "PERN6_RECEPT") nc = nc + 1)
    when(axlDBCreatePath(axlPathStart(list(list(2226.551 1749.367) list(2217.551 1758.367)) 5.400) "ETCH/TOP" "PERN6_RECEPT") nc = nc + 1)
    when(axlDBCreatePath(axlPathStart(list(list(2217.551 1758.367) list(2217.551 1797.700)) 5.400) "ETCH/TOP" "PERN6_RECEPT") nc = nc + 1)
    when(axlDBCreatePath(axlPathStart(list(list(2217.551 1797.700) list(2204.551 1810.700)) 5.400) "ETCH/TOP" "PERN6_RECEPT") nc = nc + 1)
    when(axlDBCreatePath(axlPathStart(list(list(2204.551 1810.700) list(2191.108 1810.700)) 5.400) "ETCH/TOP" "PERN6_RECEPT") nc = nc + 1)
    when(axlDBCreatePath(axlPathStart(list(list(2191.108 1810.700) list(2172.465 1829.343)) 5.400) "ETCH/TOP" "PERN6_RECEPT") nc = nc + 1)
    when(axlDBCreatePath(axlPathStart(list(list(2172.465 1829.343) list(2172.465 1841.785)) 5.400) "ETCH/TOP" "PERN6_RECEPT") nc = nc + 1)
    when(axlDBCreatePath(axlPathStart(list(list(2172.465 1841.785) list(2163.412 1850.838)) 5.400) "ETCH/TOP" "PERN6_RECEPT") nc = nc + 1)
    when(axlDBCreatePath(axlPathStart(list(list(2163.412 1850.838) list(2150.970 1850.838)) 5.400) "ETCH/TOP" "PERN6_RECEPT") nc = nc + 1)
    when(axlDBCreatePath(axlPathStart(list(list(2150.970 1850.838) list(2141.917 1859.891)) 5.400) "ETCH/TOP" "PERN6_RECEPT") nc = nc + 1)
    when(axlDBCreatePath(axlPathStart(list(list(2141.917 1859.891) list(2141.917 1872.333)) 5.400) "ETCH/TOP" "PERN6_RECEPT") nc = nc + 1)
    when(axlDBCreatePath(axlPathStart(list(list(2032.994 1772.700) list(2137.551 1668.143)) 5.400) "ETCH/BOTTOM" "PETP7_RECEPT") nc = nc + 1)
    when(axlDBCreatePath(axlPathStart(list(list(2137.551 1668.143) list(2137.551 1623.143)) 5.400) "ETCH/BOTTOM" "PETP7_RECEPT") nc = nc + 1)
    when(axlDBCreatePath(axlPathStart(list(list(2137.551 1623.143) list(2147.551 1613.143)) 5.400) "ETCH/BOTTOM" "PETP7_RECEPT") nc = nc + 1)
    when(axlDBCreatePath(axlPathStart(list(list(2147.551 1613.143) list(2147.551 1586.181)) 5.400) "ETCH/BOTTOM" "PETP7_RECEPT") nc = nc + 1)
    when(axlDBCreatePath(axlPathStart(list(list(2147.551 1586.181) list(2165.756 1567.976)) 5.400) "ETCH/BOTTOM" "PETP7_RECEPT") nc = nc + 1)
    when(axlDBCreateVia("VIA10_20-FBD" list(2165.756 1567.976) "PETP7_RECEPT") nv = nv + 1)
    when(axlDBCreatePath(axlPathStart(list(list(2185.441 1548.291) list(2165.756 1567.976)) 5.000) "ETCH/TOP" "PETP7_RECEPT") nc = nc + 1)
    when(axlDBCreatePath(axlPathStart(list(list(2165.756 1607.346) list(2163.951 1607.346)) 5.400) "ETCH/BOTTOM" "PETN7_RECEPT") nc = nc + 1)
    when(axlDBCreatePath(axlPathStart(list(list(2163.951 1607.346) list(2158.551 1612.746)) 5.400) "ETCH/BOTTOM" "PETN7_RECEPT") nc = nc + 1)
    when(axlDBCreatePath(axlPathStart(list(list(2158.551 1612.746) list(2158.551 1617.700)) 5.400) "ETCH/BOTTOM" "PETN7_RECEPT") nc = nc + 1)
    when(axlDBCreatePath(axlPathStart(list(list(2158.551 1617.700) list(2148.551 1627.700)) 5.400) "ETCH/BOTTOM" "PETN7_RECEPT") nc = nc + 1)
    when(axlDBCreatePath(axlPathStart(list(list(2148.551 1627.700) list(2148.551 1672.700)) 5.400) "ETCH/BOTTOM" "PETN7_RECEPT") nc = nc + 1)
    when(axlDBCreatePath(axlPathStart(list(list(2148.551 1672.700) list(2137.953 1683.298)) 5.400) "ETCH/BOTTOM" "PETN7_RECEPT") nc = nc + 1)
    when(axlDBCreatePath(axlPathStart(list(list(2137.953 1683.298) list(2137.953 1698.297)) 5.400) "ETCH/BOTTOM" "PETN7_RECEPT") nc = nc + 1)
    when(axlDBCreatePath(axlPathStart(list(list(2137.953 1698.297) list(2130.178 1706.072)) 5.400) "ETCH/BOTTOM" "PETN7_RECEPT") nc = nc + 1)
    when(axlDBCreatePath(axlPathStart(list(list(2130.178 1706.072) list(2115.179 1706.072)) 5.400) "ETCH/BOTTOM" "PETN7_RECEPT") nc = nc + 1)
    when(axlDBCreatePath(axlPathStart(list(list(2115.179 1706.072) list(2107.405 1713.846)) 5.400) "ETCH/BOTTOM" "PETN7_RECEPT") nc = nc + 1)
    when(axlDBCreatePath(axlPathStart(list(list(2107.405 1713.846) list(2107.405 1726.845)) 5.400) "ETCH/BOTTOM" "PETN7_RECEPT") nc = nc + 1)
    when(axlDBCreatePath(axlPathStart(list(list(2107.405 1726.845) list(2097.630 1736.620)) 5.400) "ETCH/BOTTOM" "PETN7_RECEPT") nc = nc + 1)
    when(axlDBCreatePath(axlPathStart(list(list(2097.630 1736.620) list(2084.631 1736.620)) 5.400) "ETCH/BOTTOM" "PETN7_RECEPT") nc = nc + 1)
    when(axlDBCreatePath(axlPathStart(list(list(2084.631 1736.620) list(2037.551 1783.700)) 5.400) "ETCH/BOTTOM" "PETN7_RECEPT") nc = nc + 1)
    when(axlDBCreatePath(axlPathStart(list(list(2185.441 1587.661) list(2165.756 1607.346)) 5.000) "ETCH/TOP" "PETN7_RECEPT") nc = nc + 1)
    when(axlDBCreateVia("VIA10_20-FBD" list(2165.756 1607.346) "PETN7_RECEPT") nv = nv + 1)
    when(axlDBCreatePath(axlPathStart(list(list(2185.441 1666.401) list(2163.551 1688.291)) 5.400) "ETCH/TOP" "PERP7_RECEPT") nc = nc + 1)
    when(axlDBCreatePath(axlPathStart(list(list(2163.551 1688.291) list(2163.551 1752.143)) 5.400) "ETCH/TOP" "PERP7_RECEPT") nc = nc + 1)
    when(axlDBCreatePath(axlPathStart(list(list(2076.257 1868.994) list(2076.257 1854.994)) 5.400) "ETCH/TOP" "PERN7_RECEPT") nc = nc + 1)
    when(axlDBCreatePath(axlPathStart(list(list(2076.257 1854.994) list(2084.531 1846.720)) 5.400) "ETCH/TOP" "PERN7_RECEPT") nc = nc + 1)
    when(axlDBCreatePath(axlPathStart(list(list(2084.531 1846.720) list(2098.531 1846.720)) 5.400) "ETCH/TOP" "PERN7_RECEPT") nc = nc + 1)
    when(axlDBCreatePath(axlPathStart(list(list(2098.531 1846.720) list(2106.805 1838.446)) 5.400) "ETCH/TOP" "PERN7_RECEPT") nc = nc + 1)
    when(axlDBCreatePath(axlPathStart(list(list(2106.805 1838.446) list(2106.805 1824.446)) 5.400) "ETCH/TOP" "PERN7_RECEPT") nc = nc + 1)
    when(axlDBCreatePath(axlPathStart(list(list(2106.805 1824.446) list(2115.079 1816.172)) 5.400) "ETCH/TOP" "PERN7_RECEPT") nc = nc + 1)
    when(axlDBCreatePath(axlPathStart(list(list(2115.079 1816.172) list(2129.079 1816.172)) 5.400) "ETCH/TOP" "PERN7_RECEPT") nc = nc + 1)
    when(axlDBCreatePath(axlPathStart(list(list(2129.079 1816.172) list(2137.353 1807.898)) 5.400) "ETCH/TOP" "PERN7_RECEPT") nc = nc + 1)
    when(axlDBCreatePath(axlPathStart(list(list(2137.353 1807.898) list(2137.353 1793.898)) 5.400) "ETCH/TOP" "PERN7_RECEPT") nc = nc + 1)
    when(axlDBCreatePath(axlPathStart(list(list(2137.353 1793.898) list(2145.627 1785.624)) 5.400) "ETCH/TOP" "PERN7_RECEPT") nc = nc + 1)
    when(axlDBCreatePath(axlPathStart(list(list(2145.627 1785.624) list(2159.627 1785.624)) 5.400) "ETCH/TOP" "PERN7_RECEPT") nc = nc + 1)
    when(axlDBCreatePath(axlPathStart(list(list(2159.627 1785.624) list(2167.901 1777.350)) 5.400) "ETCH/TOP" "PERN7_RECEPT") nc = nc + 1)
    when(axlDBCreatePath(axlPathStart(list(list(2167.901 1777.350) list(2167.901 1763.350)) 5.400) "ETCH/TOP" "PERN7_RECEPT") nc = nc + 1)
    when(axlDBCreatePath(axlPathStart(list(list(2167.901 1763.350) list(2178.551 1752.700)) 5.400) "ETCH/TOP" "PERN7_RECEPT") nc = nc + 1)
    when(axlDBCreatePath(axlPathStart(list(list(2178.551 1752.700) list(2178.551 1739.700)) 5.400) "ETCH/TOP" "PERN7_RECEPT") nc = nc + 1)
    when(axlDBCreatePath(axlPathStart(list(list(2178.551 1739.700) list(2174.551 1735.700)) 5.400) "ETCH/TOP" "PERN7_RECEPT") nc = nc + 1)
    when(axlDBCreatePath(axlPathStart(list(list(2174.551 1735.700) list(2174.551 1716.662)) 5.400) "ETCH/TOP" "PERN7_RECEPT") nc = nc + 1)
    when(axlDBCreatePath(axlPathStart(list(list(2174.551 1716.662) list(2185.441 1705.772)) 5.400) "ETCH/TOP" "PERN7_RECEPT") nc = nc + 1)
    when(axlDBCreatePath(axlPathStart(list(list(2146.071 1390.811) list(2126.426 1410.456)) 5.000) "ETCH/TOP" "CHIP_MODE0") nc = nc + 1)
    when(axlDBCreateVia("VIA10_20-FBD" list(2126.426 1410.456) "CHIP_MODE0") nv = nv + 1)
    when(axlDBCreatePath(axlPathStart(list(list(2146.071 1430.181) list(2126.432 1449.820)) 5.000) "ETCH/TOP" "CHIP_MODE1") nc = nc + 1)
    when(axlDBCreateVia("VIA10_20-FBD" list(2126.432 1449.820) "CHIP_MODE1") nv = nv + 1)
    when(axlDBCreatePath(axlPathStart(list(list(2106.701 1233.331) list(2087.016 1213.646)) 5.000) "ETCH/TOP" "PORTCFG[0]") nc = nc + 1)
    when(axlDBCreateVia("VIA10_20-FBD" list(2087.016 1213.646) "PORTCFG[0]") nv = nv + 1)
    when(axlDBCreatePath(axlPathStart(list(list(2146.071 1272.701) list(2126.386 1253.016)) 5.000) "ETCH/TOP" "PORTCFG[1]") nc = nc + 1)
    when(axlDBCreateVia("VIA10_20-FBD" list(2126.386 1253.016) "PORTCFG[1]") nv = nv + 1)
    when(axlDBCreatePath(axlPathStart(list(list(2106.701 1312.071) list(2087.052 1331.720)) 5.000) "ETCH/TOP" "PORTCFG[2]") nc = nc + 1)
    when(axlDBCreateVia("VIA10_20-FBD" list(2087.052 1331.720) "PORTCFG[2]") nv = nv + 1)
    when(axlDBCreatePath(axlPathStart(list(list(1923.551 1607.700) list(1933.551 1607.700)) 5.000) "ETCH/TOP" "SCL_I2C") nc = nc + 1)
    when(axlDBCreatePath(axlPathStart(list(list(1933.551 1607.700) list(1953.590 1587.661)) 5.000) "ETCH/TOP" "SCL_I2C") nc = nc + 1)
    when(axlDBCreatePath(axlPathStart(list(list(1953.590 1587.661) list(2027.960 1587.661)) 5.000) "ETCH/TOP" "SCL_I2C") nc = nc + 1)
    when(axlDBCreateVia("VIA10_20-FBD" list(1923.551 1607.700) "SCL_I2C") nv = nv + 1)
    when(axlDBCreatePath(axlPathStart(list(list(1923.551 1607.700) list(1859.551 1671.700)) 5.000) "ETCH/BOTTOM" "SCL_I2C") nc = nc + 1)
    when(axlDBCreateVia("VIA10_20-FBD" list(1958.551 1372.700) "PORTGOOD_L[1]") nv = nv + 1)
    when(axlDBCreatePath(axlPathStart(list(list(2027.960 1351.441) list(1979.810 1351.441)) 5.000) "ETCH/TOP" "PORTGOOD_L[1]") nc = nc + 1)
    when(axlDBCreatePath(axlPathStart(list(list(1979.810 1351.441) list(1958.551 1372.700)) 5.000) "ETCH/TOP" "PORTGOOD_L[1]") nc = nc + 1)
    when(axlDBCreateVia("VIA10_20-FBD" list(1988.551 1402.700) "PORTGOOD_L[2]") nv = nv + 1)
    when(axlDBCreatePath(axlPathStart(list(list(1988.551 1402.700) list(2000.440 1390.811)) 5.000) "ETCH/TOP" "PORTGOOD_L[2]") nc = nc + 1)
    when(axlDBCreatePath(axlPathStart(list(list(2000.440 1390.811) list(2027.960 1390.811)) 5.000) "ETCH/TOP" "PORTGOOD_L[2]") nc = nc + 1)
    when(axlDBCreateVia("VIA10_20-FBD" list(2087.062 1410.450) "PORTGOOD_L[3]") nv = nv + 1)
    when(axlDBCreatePath(axlPathStart(list(list(2106.701 1390.811) list(2087.062 1410.450)) 5.000) "ETCH/TOP" "PORTGOOD_L[3]") nc = nc + 1)
    when(axlDBCreatePath(axlPathStart(list(list(1913.551 1462.700) list(1946.070 1430.181)) 5.000) "ETCH/TOP" "PORTGOOD_L[4]") nc = nc + 1)
    when(axlDBCreatePath(axlPathStart(list(list(1946.070 1430.181) list(2027.960 1430.181)) 5.000) "ETCH/TOP" "PORTGOOD_L[4]") nc = nc + 1)
    when(axlDBCreateVia("VIA10_20-FBD" list(1913.551 1462.700) "PORTGOOD_L[4]") nv = nv + 1)
    when(axlDBCreateVia("VIA10_20-FBD" list(2087.066 1449.816) "PORTGOOD_L[5]") nv = nv + 1)
    when(axlDBCreatePath(axlPathStart(list(list(2106.701 1430.181) list(2087.066 1449.816)) 5.000) "ETCH/TOP" "PORTGOOD_L[5]") nc = nc + 1)
    when(axlDBCreatePath(axlPathStart(list(list(1963.551 1472.700) list(1986.551 1449.700)) 5.000) "ETCH/TOP" "PORTGOOD_L[6]") nc = nc + 1)
    when(axlDBCreatePath(axlPathStart(list(list(1986.551 1449.700) list(2047.812 1449.700)) 5.000) "ETCH/TOP" "PORTGOOD_L[6]") nc = nc + 1)
    when(axlDBCreatePath(axlPathStart(list(list(2047.812 1449.700) list(2067.331 1430.181)) 5.000) "ETCH/TOP" "PORTGOOD_L[6]") nc = nc + 1)
    when(axlDBCreateVia("VIA10_20-FBD" list(1963.551 1472.700) "PORTGOOD_L[6]") nv = nv + 1)
    when(axlDBCreateVia("VIA10_20-FBD" list(2003.551 1469.551) "PORTGOOD_L[7]") nv = nv + 1)
    when(axlDBCreatePath(axlPathStart(list(list(2003.551 1469.551) list(2027.960 1469.551)) 5.000) "ETCH/TOP" "PORTGOOD_L[7]") nc = nc + 1)
    when(axlDBCreatePath(axlPathStart(list(list(1913.551 1367.700) list(1938.551 1392.700)) 5.000) "ETCH/TOP" "PORTGOOD_L[0]") nc = nc + 1)
    when(axlDBCreatePath(axlPathStart(list(list(1938.551 1392.700) list(1968.551 1392.700)) 5.000) "ETCH/TOP" "PORTGOOD_L[0]") nc = nc + 1)
    when(axlDBCreatePath(axlPathStart(list(list(1968.551 1392.700) list(1991.633 1369.618)) 5.000) "ETCH/TOP" "PORTGOOD_L[0]") nc = nc + 1)
    when(axlDBCreatePath(axlPathStart(list(list(1991.633 1369.618) list(2049.154 1369.618)) 5.000) "ETCH/TOP" "PORTGOOD_L[0]") nc = nc + 1)
    when(axlDBCreatePath(axlPathStart(list(list(2049.154 1369.618) list(2067.331 1351.441)) 5.000) "ETCH/TOP" "PORTGOOD_L[0]") nc = nc + 1)
    when(axlDBCreateVia("VIA10_20-FBD" list(1913.551 1367.700) "PORTGOOD_L[0]") nv = nv + 1)
    when(axlDBCreatePath(axlPathStart(list(list(2636.681 1073.508) list(2636.681 1083.830)) 4.000) "ETCH/ART03" "REFCLKOP7") nc = nc + 1)
    when(axlDBCreatePath(axlPathStart(list(list(2636.681 1083.830) list(2642.834 1089.983)) 4.000) "ETCH/ART03" "REFCLKOP7") nc = nc + 1)
    when(axlDBCreatePath(axlPathStart(list(list(2642.834 1089.983) list(2653.156 1089.983)) 4.000) "ETCH/ART03" "REFCLKOP7") nc = nc + 1)
    when(axlDBCreatePath(axlPathStart(list(list(2653.156 1089.983) list(2659.309 1096.136)) 4.000) "ETCH/ART03" "REFCLKOP7") nc = nc + 1)
    when(axlDBCreatePath(axlPathStart(list(list(2659.309 1096.136) list(2659.309 1106.458)) 4.000) "ETCH/ART03" "REFCLKOP7") nc = nc + 1)
    when(axlDBCreatePath(axlPathStart(list(list(2659.309 1106.458) list(2665.462 1112.611)) 4.000) "ETCH/ART03" "REFCLKOP7") nc = nc + 1)
    when(axlDBCreatePath(axlPathStart(list(list(2665.462 1112.611) list(2675.784 1112.611)) 4.000) "ETCH/ART03" "REFCLKOP7") nc = nc + 1)
    when(axlDBCreatePath(axlPathStart(list(list(2675.784 1112.611) list(2681.937 1118.764)) 4.000) "ETCH/ART03" "REFCLKOP7") nc = nc + 1)
    when(axlDBCreatePath(axlPathStart(list(list(2681.937 1118.764) list(2681.937 1129.086)) 4.000) "ETCH/ART03" "REFCLKOP7") nc = nc + 1)
    when(axlDBCreatePath(axlPathStart(list(list(2681.937 1129.086) list(2688.090 1135.239)) 4.000) "ETCH/ART03" "REFCLKOP7") nc = nc + 1)
    when(axlDBCreatePath(axlPathStart(list(list(2688.090 1135.239) list(2698.412 1135.239)) 4.000) "ETCH/ART03" "REFCLKOP7") nc = nc + 1)
    when(axlDBCreatePath(axlPathStart(list(list(2698.412 1135.239) list(2704.565 1141.392)) 4.000) "ETCH/ART03" "REFCLKOP7") nc = nc + 1)
    when(axlDBCreatePath(axlPathStart(list(list(2704.565 1141.392) list(2704.565 1151.714)) 4.000) "ETCH/ART03" "REFCLKOP7") nc = nc + 1)
    when(axlDBCreatePath(axlPathStart(list(list(2708.551 1234.593) list(2694.990 1248.154)) 4.000) "ETCH/TOP" "REFCLKOP7") nc = nc + 1)
    when(axlDBCreatePath(axlPathStart(list(list(2694.990 1248.154) list(2683.248 1248.154)) 4.000) "ETCH/TOP" "REFCLKOP7") nc = nc + 1)
    when(axlDBCreatePath(axlPathStart(list(list(2683.248 1248.154) list(2673.051 1258.351)) 4.000) "ETCH/TOP" "REFCLKOP7") nc = nc + 1)
    when(axlDBCreatePath(axlPathStart(list(list(2673.051 1258.351) list(2673.051 1323.200)) 4.000) "ETCH/TOP" "REFCLKOP7") nc = nc + 1)
    when(axlDBCreatePath(axlPathStart(list(list(2673.051 1323.200) list(2638.551 1357.700)) 4.000) "ETCH/TOP" "REFCLKOP7") nc = nc + 1)
    when(axlDBCreatePath(axlPathStart(list(list(2638.551 1357.700) list(2598.701 1357.700)) 4.000) "ETCH/TOP" "REFCLKOP7") nc = nc + 1)
    when(axlDBCreatePath(axlPathStart(list(list(2598.701 1357.700) list(2588.701 1367.700)) 4.000) "ETCH/TOP" "REFCLKOP7") nc = nc + 1)
    when(axlDBCreatePath(axlPathStart(list(list(2588.701 1367.700) list(2523.512 1367.700)) 4.000) "ETCH/TOP" "REFCLKOP7") nc = nc + 1)
    when(axlDBCreatePath(axlPathStart(list(list(2523.512 1367.700) list(2500.401 1390.811)) 4.000) "ETCH/TOP" "REFCLKOP7") nc = nc + 1)
    when(axlDBCreateVia("VIA10_20-FBD" list(2708.551 1234.593) "REFCLKOP7") nv = nv + 1)
    when(axlDBCreatePath(axlPathStart(list(list(2708.551 1270.607) list(2696.598 1258.654)) 4.000) "ETCH/TOP" "REFCLKON7") nc = nc + 1)
    when(axlDBCreatePath(axlPathStart(list(list(2696.598 1258.654) list(2687.598 1258.654)) 4.000) "ETCH/TOP" "REFCLKON7") nc = nc + 1)
    when(axlDBCreatePath(axlPathStart(list(list(2687.598 1258.654) list(2683.551 1262.701)) 4.000) "ETCH/TOP" "REFCLKON7") nc = nc + 1)
    when(axlDBCreatePath(axlPathStart(list(list(2683.551 1262.701) list(2683.551 1327.550)) 4.000) "ETCH/TOP" "REFCLKON7") nc = nc + 1)
    when(axlDBCreatePath(axlPathStart(list(list(2683.551 1327.550) list(2642.901 1368.200)) 4.000) "ETCH/TOP" "REFCLKON7") nc = nc + 1)
    when(axlDBCreatePath(axlPathStart(list(list(2642.901 1368.200) list(2603.051 1368.200)) 4.000) "ETCH/TOP" "REFCLKON7") nc = nc + 1)
    when(axlDBCreatePath(axlPathStart(list(list(2603.051 1368.200) list(2593.051 1378.200)) 4.000) "ETCH/TOP" "REFCLKON7") nc = nc + 1)
    when(axlDBCreatePath(axlPathStart(list(list(2593.051 1378.200) list(2583.883 1378.200)) 4.000) "ETCH/TOP" "REFCLKON7") nc = nc + 1)
    when(axlDBCreatePath(axlPathStart(list(list(2583.883 1378.200) list(2576.383 1385.700)) 4.000) "ETCH/TOP" "REFCLKON7") nc = nc + 1)
    when(axlDBCreatePath(axlPathStart(list(list(2576.383 1385.700) list(2567.883 1385.700)) 4.000) "ETCH/TOP" "REFCLKON7") nc = nc + 1)
    when(axlDBCreatePath(axlPathStart(list(list(2567.883 1385.700) list(2560.383 1378.200)) 4.000) "ETCH/TOP" "REFCLKON7") nc = nc + 1)
    when(axlDBCreatePath(axlPathStart(list(list(2560.383 1378.200) list(2552.383 1378.200)) 4.000) "ETCH/TOP" "REFCLKON7") nc = nc + 1)
    when(axlDBCreatePath(axlPathStart(list(list(2552.383 1378.200) list(2539.772 1390.811)) 4.000) "ETCH/TOP" "REFCLKON7") nc = nc + 1)
    when(axlDBCreateVia("VIA10_20-FBD" list(2708.551 1270.607) "REFCLKON7") nv = nv + 1)
    when(axlDBCreatePath(axlPathStart(list(list(2106.701 1587.661) list(2087.016 1607.346)) 5.000) "ETCH/TOP" "I2C_ADDR0") nc = nc + 1)
    when(axlDBCreateVia("VIA10_20-FBD" list(2087.016 1607.346) "I2C_ADDR0") nv = nv + 1)
    when(axlDBCreatePath(axlPathStart(list(list(2687.465 1168.355) list(2687.465 1247.528)) 4.000) "ETCH/ART03" "REFCLKON6") nc = nc + 1)
    when(axlDBCreatePath(axlPathStart(list(list(2687.465 1247.528) list(2676.143 1258.850)) 4.000) "ETCH/ART03" "REFCLKON6") nc = nc + 1)
    when(axlDBCreatePath(axlPathStart(list(list(2676.143 1258.850) list(2665.308 1258.850)) 4.000) "ETCH/ART03" "REFCLKON6") nc = nc + 1)
    when(axlDBCreatePath(axlPathStart(list(list(2665.308 1258.850) list(2653.551 1270.607)) 4.000) "ETCH/ART03" "REFCLKON6") nc = nc + 1)
    when(axlDBCreatePath(axlPathStart(list(list(2539.772 1351.441) list(2551.968 1339.244)) 4.000) "ETCH/TOP" "REFCLKON6") nc = nc + 1)
    when(axlDBCreatePath(axlPathStart(list(list(2551.968 1339.244) list(2568.642 1322.571)) 4.000) "ETCH/TOP" "REFCLKON6") nc = nc + 1)
    when(axlDBCreatePath(axlPathStart(list(list(2568.642 1322.571) list(2583.680 1322.571)) 4.000) "ETCH/TOP" "REFCLKON6") nc = nc + 1)
    when(axlDBCreatePath(axlPathStart(list(list(2583.680 1322.571) list(2635.644 1270.607)) 4.000) "ETCH/TOP" "REFCLKON6") nc = nc + 1)
    when(axlDBCreatePath(axlPathStart(list(list(2635.644 1270.607) list(2653.551 1270.607)) 4.000) "ETCH/TOP" "REFCLKON6") nc = nc + 1)
    when(axlDBCreateVia("VIA10_20-FBD" list(2653.551 1270.607) "REFCLKON6") nv = nv + 1)
    when(axlDBCreatePath(axlPathStart(list(list(2583.902 1082.470) list(2583.902 1092.051)) 4.000) "ETCH/ART03" "REFCLKOP6") nc = nc + 1)
    when(axlDBCreatePath(axlPathStart(list(list(2583.902 1092.051) list(2590.426 1098.575)) 4.000) "ETCH/ART03" "REFCLKOP6") nc = nc + 1)
    when(axlDBCreatePath(axlPathStart(list(list(2590.426 1098.575) list(2600.007 1098.575)) 4.000) "ETCH/ART03" "REFCLKOP6") nc = nc + 1)
    when(axlDBCreatePath(axlPathStart(list(list(2600.007 1098.575) list(2606.530 1105.098)) 4.000) "ETCH/ART03" "REFCLKOP6") nc = nc + 1)
    when(axlDBCreatePath(axlPathStart(list(list(2606.530 1105.098) list(2606.530 1114.679)) 4.000) "ETCH/ART03" "REFCLKOP6") nc = nc + 1)
    when(axlDBCreatePath(axlPathStart(list(list(2606.530 1114.679) list(2613.054 1121.203)) 4.000) "ETCH/ART03" "REFCLKOP6") nc = nc + 1)
    when(axlDBCreatePath(axlPathStart(list(list(2613.054 1121.203) list(2622.635 1121.203)) 4.000) "ETCH/ART03" "REFCLKOP6") nc = nc + 1)
    when(axlDBCreatePath(axlPathStart(list(list(2622.635 1121.203) list(2629.158 1127.726)) 4.000) "ETCH/ART03" "REFCLKOP6") nc = nc + 1)
    when(axlDBCreatePath(axlPathStart(list(list(2629.158 1127.726) list(2629.158 1137.307)) 4.000) "ETCH/ART03" "REFCLKOP6") nc = nc + 1)
    when(axlDBCreatePath(axlPathStart(list(list(2629.158 1137.307) list(2635.682 1143.831)) 4.000) "ETCH/ART03" "REFCLKOP6") nc = nc + 1)
    when(axlDBCreatePath(axlPathStart(list(list(2635.682 1143.831) list(2645.263 1143.831)) 4.000) "ETCH/ART03" "REFCLKOP6") nc = nc + 1)
    when(axlDBCreatePath(axlPathStart(list(list(2645.263 1143.831) list(2651.786 1150.354)) 4.000) "ETCH/ART03" "REFCLKOP6") nc = nc + 1)
    when(axlDBCreatePath(axlPathStart(list(list(2651.786 1150.354) list(2651.786 1159.935)) 4.000) "ETCH/ART03" "REFCLKOP6") nc = nc + 1)
    when(axlDBCreatePath(axlPathStart(list(list(2651.786 1159.935) list(2658.310 1166.459)) 4.000) "ETCH/ART03" "REFCLKOP6") nc = nc + 1)
    when(axlDBCreatePath(axlPathStart(list(list(2658.310 1166.459) list(2667.891 1166.459)) 4.000) "ETCH/ART03" "REFCLKOP6") nc = nc + 1)
    when(axlDBCreatePath(axlPathStart(list(list(2667.891 1166.459) list(2674.965 1173.533)) 4.000) "ETCH/ART03" "REFCLKOP6") nc = nc + 1)
    when(axlDBCreatePath(axlPathStart(list(list(2674.965 1173.533) list(2674.965 1242.350)) 4.000) "ETCH/ART03" "REFCLKOP6") nc = nc + 1)
    when(axlDBCreatePath(axlPathStart(list(list(2674.965 1242.350) list(2670.965 1246.350)) 4.000) "ETCH/ART03" "REFCLKOP6") nc = nc + 1)
    when(axlDBCreatePath(axlPathStart(list(list(2670.965 1246.350) list(2665.308 1246.350)) 4.000) "ETCH/ART03" "REFCLKOP6") nc = nc + 1)
    when(axlDBCreatePath(axlPathStart(list(list(2665.308 1246.350) list(2653.551 1234.593)) 4.000) "ETCH/ART03" "REFCLKOP6") nc = nc + 1)
    when(axlDBCreatePath(axlPathStart(list(list(2653.551 1234.593) list(2653.551 1237.850)) 4.000) "ETCH/TOP" "REFCLKOP6") nc = nc + 1)
    when(axlDBCreatePath(axlPathStart(list(list(2653.551 1237.850) list(2626.588 1264.813)) 4.000) "ETCH/TOP" "REFCLKOP6") nc = nc + 1)
    when(axlDBCreatePath(axlPathStart(list(list(2626.588 1264.813) list(2615.438 1264.813)) 4.000) "ETCH/TOP" "REFCLKOP6") nc = nc + 1)
    when(axlDBCreatePath(axlPathStart(list(list(2615.438 1264.813) list(2609.699 1270.552)) 4.000) "ETCH/TOP" "REFCLKOP6") nc = nc + 1)
    when(axlDBCreatePath(axlPathStart(list(list(2609.699 1270.552) list(2609.699 1281.702)) 4.000) "ETCH/TOP" "REFCLKOP6") nc = nc + 1)
    when(axlDBCreatePath(axlPathStart(list(list(2609.699 1281.702) list(2603.960 1287.441)) 4.000) "ETCH/TOP" "REFCLKOP6") nc = nc + 1)
    when(axlDBCreatePath(axlPathStart(list(list(2603.960 1287.441) list(2592.810 1287.441)) 4.000) "ETCH/TOP" "REFCLKOP6") nc = nc + 1)
    when(axlDBCreatePath(axlPathStart(list(list(2592.810 1287.441) list(2587.071 1293.180)) 4.000) "ETCH/TOP" "REFCLKOP6") nc = nc + 1)
    when(axlDBCreatePath(axlPathStart(list(list(2587.071 1293.180) list(2587.071 1304.330)) 4.000) "ETCH/TOP" "REFCLKOP6") nc = nc + 1)
    when(axlDBCreatePath(axlPathStart(list(list(2587.071 1304.330) list(2579.330 1312.071)) 4.000) "ETCH/TOP" "REFCLKOP6") nc = nc + 1)
    when(axlDBCreatePath(axlPathStart(list(list(2579.330 1312.071) list(2564.292 1312.071)) 4.000) "ETCH/TOP" "REFCLKOP6") nc = nc + 1)
    when(axlDBCreatePath(axlPathStart(list(list(2564.292 1312.071) list(2548.412 1327.951)) 4.000) "ETCH/TOP" "REFCLKOP6") nc = nc + 1)
    when(axlDBCreatePath(axlPathStart(list(list(2548.412 1327.951) list(2540.675 1327.951)) 4.000) "ETCH/TOP" "REFCLKOP6") nc = nc + 1)
    when(axlDBCreatePath(axlPathStart(list(list(2540.675 1327.951) list(2536.675 1323.951)) 4.000) "ETCH/TOP" "REFCLKOP6") nc = nc + 1)
    when(axlDBCreatePath(axlPathStart(list(list(2536.675 1323.951) list(2536.675 1315.168)) 4.000) "ETCH/TOP" "REFCLKOP6") nc = nc + 1)
    when(axlDBCreatePath(axlPathStart(list(list(2536.675 1315.168) list(2539.772 1312.071)) 4.000) "ETCH/TOP" "REFCLKOP6") nc = nc + 1)
    when(axlDBCreateVia("VIA10_20-FBD" list(2653.551 1234.593) "REFCLKOP6") nv = nv + 1)
    when(axlDBCreatePath(axlPathStart(list(list(2626.051 1166.522) list(2626.051 1273.878)) 4.000) "ETCH/ART03" "REFCLKOP5") nc = nc + 1)
    when(axlDBCreatePath(axlPathStart(list(list(2626.051 1273.878) list(2590.229 1309.700)) 4.000) "ETCH/ART03" "REFCLKOP5") nc = nc + 1)
    when(axlDBCreatePath(axlPathStart(list(list(2590.229 1309.700) list(2497.982 1309.700)) 4.000) "ETCH/ART03" "REFCLKOP5") nc = nc + 1)
    when(axlDBCreatePath(axlPathStart(list(list(2497.982 1309.700) list(2480.692 1292.410)) 4.000) "ETCH/ART03" "REFCLKOP5") nc = nc + 1)
    when(axlDBCreateVia("VIA10_20-FBD" list(2480.692 1292.410) "REFCLKOP5") nv = nv + 1)
    when(axlDBCreatePath(axlPathStart(list(list(2461.031 1312.071) list(2480.692 1292.410)) 5.000) "ETCH/TOP" "REFCLKOP5") nc = nc + 1)
    when(axlDBCreatePath(axlPathStart(list(list(2475.428 1033.577) list(2475.428 1044.577)) 4.000) "ETCH/ART03" "REFCLKON5") nc = nc + 1)
    when(axlDBCreatePath(axlPathStart(list(list(2475.428 1044.577) list(2481.242 1050.391)) 4.000) "ETCH/ART03" "REFCLKON5") nc = nc + 1)
    when(axlDBCreatePath(axlPathStart(list(list(2481.242 1050.391) list(2492.242 1050.391)) 4.000) "ETCH/ART03" "REFCLKON5") nc = nc + 1)
    when(axlDBCreatePath(axlPathStart(list(list(2492.242 1050.391) list(2498.056 1056.205)) 4.000) "ETCH/ART03" "REFCLKON5") nc = nc + 1)
    when(axlDBCreatePath(axlPathStart(list(list(2498.056 1056.205) list(2498.056 1067.205)) 4.000) "ETCH/ART03" "REFCLKON5") nc = nc + 1)
    when(axlDBCreatePath(axlPathStart(list(list(2498.056 1067.205) list(2503.870 1073.019)) 4.000) "ETCH/ART03" "REFCLKON5") nc = nc + 1)
    when(axlDBCreatePath(axlPathStart(list(list(2503.870 1073.019) list(2514.870 1073.019)) 4.000) "ETCH/ART03" "REFCLKON5") nc = nc + 1)
    when(axlDBCreatePath(axlPathStart(list(list(2514.870 1073.019) list(2522.279 1080.428)) 4.000) "ETCH/ART03" "REFCLKON5") nc = nc + 1)
    when(axlDBCreatePath(axlPathStart(list(list(2522.279 1080.428) list(2522.279 1090.428)) 4.000) "ETCH/ART03" "REFCLKON5") nc = nc + 1)
    when(axlDBCreatePath(axlPathStart(list(list(2522.279 1090.428) list(2528.593 1096.742)) 4.000) "ETCH/ART03" "REFCLKON5") nc = nc + 1)
    when(axlDBCreatePath(axlPathStart(list(list(2528.593 1096.742) list(2538.593 1096.742)) 4.000) "ETCH/ART03" "REFCLKON5") nc = nc + 1)
    when(axlDBCreatePath(axlPathStart(list(list(2538.593 1096.742) list(2544.907 1103.056)) 4.000) "ETCH/ART03" "REFCLKON5") nc = nc + 1)
    when(axlDBCreatePath(axlPathStart(list(list(2544.907 1103.056) list(2544.907 1113.056)) 4.000) "ETCH/ART03" "REFCLKON5") nc = nc + 1)
    when(axlDBCreatePath(axlPathStart(list(list(2544.907 1113.056) list(2551.221 1119.370)) 4.000) "ETCH/ART03" "REFCLKON5") nc = nc + 1)
    when(axlDBCreatePath(axlPathStart(list(list(2551.221 1119.370) list(2561.221 1119.370)) 4.000) "ETCH/ART03" "REFCLKON5") nc = nc + 1)
    when(axlDBCreatePath(axlPathStart(list(list(2561.221 1119.370) list(2567.535 1125.684)) 4.000) "ETCH/ART03" "REFCLKON5") nc = nc + 1)
    when(axlDBCreatePath(axlPathStart(list(list(2567.535 1125.684) list(2567.535 1135.684)) 4.000) "ETCH/ART03" "REFCLKON5") nc = nc + 1)
    when(axlDBCreatePath(axlPathStart(list(list(2567.535 1135.684) list(2573.849 1141.998)) 4.000) "ETCH/ART03" "REFCLKON5") nc = nc + 1)
    when(axlDBCreatePath(axlPathStart(list(list(2573.849 1141.998) list(2583.849 1141.998)) 4.000) "ETCH/ART03" "REFCLKON5") nc = nc + 1)
    when(axlDBCreatePath(axlPathStart(list(list(2583.849 1141.998) list(2590.163 1148.312)) 4.000) "ETCH/ART03" "REFCLKON5") nc = nc + 1)
    when(axlDBCreatePath(axlPathStart(list(list(2590.163 1148.312) list(2590.163 1158.312)) 4.000) "ETCH/ART03" "REFCLKON5") nc = nc + 1)
    when(axlDBCreatePath(axlPathStart(list(list(2590.163 1158.312) list(2596.477 1164.626)) 4.000) "ETCH/ART03" "REFCLKON5") nc = nc + 1)
    when(axlDBCreatePath(axlPathStart(list(list(2596.477 1164.626) list(2606.477 1164.626)) 4.000) "ETCH/ART03" "REFCLKON5") nc = nc + 1)
    when(axlDBCreatePath(axlPathStart(list(list(2606.477 1164.626) list(2613.551 1171.700)) 4.000) "ETCH/ART03" "REFCLKON5") nc = nc + 1)
    when(axlDBCreatePath(axlPathStart(list(list(2613.551 1171.700) list(2613.551 1203.700)) 4.000) "ETCH/ART03" "REFCLKON5") nc = nc + 1)
    when(axlDBCreatePath(axlPathStart(list(list(2613.551 1203.700) list(2606.551 1210.700)) 4.000) "ETCH/ART03" "REFCLKON5") nc = nc + 1)
    when(axlDBCreatePath(axlPathStart(list(list(2606.551 1210.700) list(2606.551 1219.700)) 4.000) "ETCH/ART03" "REFCLKON5") nc = nc + 1)
    when(axlDBCreatePath(axlPathStart(list(list(2606.551 1219.700) list(2613.551 1226.700)) 4.000) "ETCH/ART03" "REFCLKON5") nc = nc + 1)
    when(axlDBCreatePath(axlPathStart(list(list(2613.551 1226.700) list(2613.551 1235.700)) 4.000) "ETCH/ART03" "REFCLKON5") nc = nc + 1)
    when(axlDBCreatePath(axlPathStart(list(list(2613.551 1235.700) list(2606.551 1242.700)) 4.000) "ETCH/ART03" "REFCLKON5") nc = nc + 1)
    when(axlDBCreatePath(axlPathStart(list(list(2606.551 1242.700) list(2606.551 1251.700)) 4.000) "ETCH/ART03" "REFCLKON5") nc = nc + 1)
    when(axlDBCreatePath(axlPathStart(list(list(2606.551 1251.700) list(2613.551 1258.700)) 4.000) "ETCH/ART03" "REFCLKON5") nc = nc + 1)
    when(axlDBCreatePath(axlPathStart(list(list(2613.551 1258.700) list(2613.551 1268.700)) 4.000) "ETCH/ART03" "REFCLKON5") nc = nc + 1)
    when(axlDBCreatePath(axlPathStart(list(list(2613.551 1268.700) list(2585.051 1297.200)) 4.000) "ETCH/ART03" "REFCLKON5") nc = nc + 1)
    when(axlDBCreatePath(axlPathStart(list(list(2585.051 1297.200) list(2524.062 1297.200)) 4.000) "ETCH/ART03" "REFCLKON5") nc = nc + 1)
    when(axlDBCreatePath(axlPathStart(list(list(2524.062 1297.200) list(2520.062 1293.200)) 4.000) "ETCH/ART03" "REFCLKON5") nc = nc + 1)
    when(axlDBCreatePath(axlPathStart(list(list(2520.062 1293.200) list(2520.062 1292.410)) 4.000) "ETCH/ART03" "REFCLKON5") nc = nc + 1)
    when(axlDBCreateVia("VIA10_20-FBD" list(2520.062 1292.410) "REFCLKON5") nv = nv + 1)
    when(axlDBCreatePath(axlPathStart(list(list(2500.401 1312.071) list(2520.062 1292.410)) 5.000) "ETCH/TOP" "REFCLKON5") nc = nc + 1)
    when(axlDBCreatePath(axlPathStart(list(list(2474.808 1101.293) list(2446.596 1129.505)) 4.000) "ETCH/TOP" "REFCLKIN_R") nc = nc + 1)
    when(axlDBCreatePath(axlPathStart(list(list(2446.596 1129.505) list(2446.596 1179.525)) 4.000) "ETCH/TOP" "REFCLKIN_R") nc = nc + 1)
    when(axlDBCreatePath(axlPathStart(list(list(2446.596 1179.525) list(2461.031 1193.960)) 4.000) "ETCH/TOP" "REFCLKIN_R") nc = nc + 1)
    when(axlDBCreatePath(axlPathStart(list(list(2283.880 1193.980) list(2283.880 1222.371)) 5.000) "ETCH/BOTTOM" "RESREF") nc = nc + 1)
    when(axlDBCreatePath(axlPathStart(list(list(2283.880 1222.371) list(2264.191 1242.060)) 5.000) "ETCH/BOTTOM" "RESREF") nc = nc + 1)
    when(axlDBCreatePath(axlPathStart(list(list(2264.191 1242.060) list(2264.191 1312.060)) 5.000) "ETCH/BOTTOM" "RESREF") nc = nc + 1)
    when(axlDBCreatePath(axlPathStart(list(list(2264.191 1312.060) list(2244.511 1331.740)) 5.000) "ETCH/BOTTOM" "RESREF") nc = nc + 1)
    when(axlDBCreateVia("VIA10_20-FBD" list(2244.511 1331.740) "RESREF") nv = nv + 1)
    when(axlDBCreatePath(axlPathStart(list(list(2264.181 1351.441) list(2244.511 1331.771)) 5.000) "ETCH/TOP" "RESREF") nc = nc + 1)
    when(axlDBCreatePath(axlPathStart(list(list(2244.511 1331.771) list(2244.511 1331.740)) 5.000) "ETCH/TOP" "RESREF") nc = nc + 1)
    when(axlDBCreatePath(axlPathStart(list(list(2433.729 1079.200) list(2548.551 1194.022)) 4.000) "ETCH/ART03" "REFCLKOP4") nc = nc + 1)
    when(axlDBCreatePath(axlPathStart(list(list(2548.551 1194.022) list(2548.551 1202.800)) 4.000) "ETCH/ART03" "REFCLKOP4") nc = nc + 1)
    when(axlDBCreatePath(axlPathStart(list(list(2548.551 1202.800) list(2559.427 1213.676)) 4.000) "ETCH/ART03" "REFCLKOP4") nc = nc + 1)
    when(axlDBCreateVia("VIA10_20-FBD" list(2559.427 1213.676) "REFCLKOP4") nv = nv + 1)
    when(axlDBCreatePath(axlPathStart(list(list(2539.772 1233.331) list(2559.427 1213.676)) 5.000) "ETCH/TOP" "REFCLKOP4") nc = nc + 1)
    when(axlDBCreatePath(axlPathStart(list(list(2428.551 1091.700) list(2536.051 1199.200)) 4.000) "ETCH/ART03" "REFCLKON4") nc = nc + 1)
    when(axlDBCreatePath(axlPathStart(list(list(2536.051 1199.200) list(2536.051 1213.770)) 4.000) "ETCH/ART03" "REFCLKON4") nc = nc + 1)
    when(axlDBCreatePath(axlPathStart(list(list(2536.051 1213.770) list(2559.427 1237.146)) 4.000) "ETCH/ART03" "REFCLKON4") nc = nc + 1)
    when(axlDBCreatePath(axlPathStart(list(list(2559.427 1237.146) list(2559.427 1253.046)) 4.000) "ETCH/ART03" "REFCLKON4") nc = nc + 1)
    when(axlDBCreateVia("VIA10_20-FBD" list(2559.427 1253.046) "REFCLKON4") nv = nv + 1)
    when(axlDBCreatePath(axlPathStart(list(list(2539.772 1272.701) list(2559.427 1253.046)) 5.000) "ETCH/TOP" "REFCLKON4") nc = nc + 1)
    when(axlDBCreatePath(axlPathStart(list(list(2464.308 1096.943) list(2436.096 1125.155)) 4.000) "ETCH/TOP" "REFCLKIP_R") nc = nc + 1)
    when(axlDBCreatePath(axlPathStart(list(list(2436.096 1125.155) list(2436.096 1179.525)) 4.000) "ETCH/TOP" "REFCLKIP_R") nc = nc + 1)
    when(axlDBCreatePath(axlPathStart(list(list(2436.096 1179.525) list(2421.661 1193.960)) 4.000) "ETCH/TOP" "REFCLKIP_R") nc = nc + 1)
    when(axlDBCreatePath(axlPathStart(list(list(1858.551 1712.700) list(1923.551 1647.700)) 5.000) "ETCH/BOTTOM" "SDA_I2C") nc = nc + 1)
    when(axlDBCreatePath(axlPathStart(list(list(1923.551 1647.700) list(1963.991 1607.260)) 5.000) "ETCH/TOP" "SDA_I2C") nc = nc + 1)
    when(axlDBCreatePath(axlPathStart(list(list(1963.991 1607.260) list(2047.732 1607.260)) 5.000) "ETCH/TOP" "SDA_I2C") nc = nc + 1)
    when(axlDBCreatePath(axlPathStart(list(list(2047.732 1607.260) list(2067.331 1587.661)) 5.000) "ETCH/TOP" "SDA_I2C") nc = nc + 1)
    when(axlDBCreateVia("VIA10_20-FBD" list(1923.551 1647.700) "SDA_I2C") nv = nv + 1)
    when(axlDBCreateVia("VIA10_20-FBD" list(2003.551 1627.700) "I2C_ADDR1") nv = nv + 1)
    when(axlDBCreatePath(axlPathStart(list(list(2027.960 1627.031) list(2004.220 1627.031)) 5.000) "ETCH/TOP" "I2C_ADDR1") nc = nc + 1)
    when(axlDBCreatePath(axlPathStart(list(list(2004.220 1627.031) list(2003.551 1627.700)) 5.000) "ETCH/TOP" "I2C_ADDR1") nc = nc + 1)
    when(axlDBCreateVia("VIA10_20-FBD" list(2441.346 1686.086) "PDC_L_7") nv = nv + 1)
    when(axlDBCreatePath(axlPathStart(list(list(2441.346 1686.086) list(2421.661 1666.401)) 5.000) "ETCH/TOP" "PDC_L_7") nc = nc + 1)
    when(axlDBCreatePath(axlPathStart(list(list(2106.701 1627.031) list(2087.016 1646.716)) 5.000) "ETCH/TOP" "I2C_ADDR2") nc = nc + 1)
    when(axlDBCreateVia("VIA10_20-FBD" list(2087.016 1646.716) "I2C_ADDR2") nv = nv + 1)
    when(axlDBCreateVia("VIA10_20-FBD" list(1988.671 1193.960) "JTAG_SEL_L") nv = nv + 1)
    when(axlDBCreatePath(axlPathStart(list(list(2027.960 1193.960) list(1988.671 1193.960)) 5.000) "ETCH/TOP" "JTAG_SEL_L") nc = nc + 1)
    when(axlDBCreatePath(axlPathStart(list(list(2067.331 1705.772) list(2040.403 1732.700)) 5.000) "ETCH/TOP" "PDC_L_0") nc = nc + 1)
    when(axlDBCreatePath(axlPathStart(list(list(2040.403 1732.700) list(1868.552 1732.700)) 5.000) "ETCH/TOP" "PDC_L_0") nc = nc + 1)
    when(axlDBCreatePath(axlPathStart(list(list(1881.623 1705.772) list(2027.960 1705.772)) 5.000) "ETCH/TOP" "PDC_L_1") nc = nc + 1)
    when(axlDBCreatePath(axlPathStart(list(list(2048.551 1782.700) list(2106.701 1724.550)) 5.000) "ETCH/TOP" "PDC_L_2") nc = nc + 1)
    when(axlDBCreatePath(axlPathStart(list(list(2106.701 1724.550) list(2106.701 1705.772)) 5.000) "ETCH/TOP" "PDC_L_2") nc = nc + 1)
    when(axlDBCreatePath(axlPathStart(list(list(2027.960 1666.401) list(1912.252 1666.401)) 5.000) "ETCH/TOP" "PDC_L_3") nc = nc + 1)
    when(axlDBCreatePath(axlPathStart(list(list(2067.331 1666.401) list(2047.711 1686.021)) 5.000) "ETCH/TOP" "PDC_L_4") nc = nc + 1)
    when(axlDBCreatePath(axlPathStart(list(list(2047.711 1686.021) list(1896.872 1686.021)) 5.000) "ETCH/TOP" "PDC_L_4") nc = nc + 1)
    when(axlDBCreatePath(axlPathStart(list(list(2043.551 1757.700) list(2087.071 1714.180)) 5.000) "ETCH/TOP" "PDC_L_5") nc = nc + 1)
    when(axlDBCreatePath(axlPathStart(list(list(2087.071 1714.180) list(2087.071 1686.031)) 5.000) "ETCH/TOP" "PDC_L_5") nc = nc + 1)
    when(axlDBCreatePath(axlPathStart(list(list(2087.071 1686.031) list(2106.701 1666.401)) 5.000) "ETCH/TOP" "PDC_L_5") nc = nc + 1)
    when(axlDBCreatePath(axlPathStart(list(list(2062.551 1803.700) list(2126.431 1739.820)) 5.000) "ETCH/TOP" "PDC_L_6") nc = nc + 1)
    when(axlDBCreatePath(axlPathStart(list(list(2126.431 1739.820) list(2126.431 1646.671)) 5.000) "ETCH/TOP" "PDC_L_6") nc = nc + 1)
    when(axlDBCreatePath(axlPathStart(list(list(2126.431 1646.671) list(2146.071 1627.031)) 5.000) "ETCH/TOP" "PDC_L_6") nc = nc + 1)
    when(axlDBCreatePath(axlPathStart(list(list(2525.336 1179.524) list(2539.772 1193.960)) 4.000) "ETCH/TOP" "REFCLKON0") nc = nc + 1)
    when(axlDBCreatePath(axlPathStart(list(list(2514.836 1179.525) list(2500.401 1193.960)) 4.000) "ETCH/TOP" "REFCLKOP0") nc = nc + 1)
    when(axlDBCreatePath(axlPathStart(list(list(2047.662 1331.740) list(2067.331 1312.071)) 5.000) "ETCH/TOP" "PERST_CHIP_L") nc = nc + 1)
    when(axlDBCreatePath(axlPathStart(list(list(2458.551 1802.700) list(2421.661 1765.810)) 5.000) "ETCH/TOP" "SHCL_I2C") nc = nc + 1)
    when(axlDBCreatePath(axlPathStart(list(list(2421.661 1765.810) list(2421.661 1705.772)) 5.000) "ETCH/TOP" "SHCL_I2C") nc = nc + 1)
    when(axlDBCreatePath(axlPathStart(list(list(2478.551 1723.292) list(2461.031 1705.772)) 5.000) "ETCH/TOP" "SHDA_I2C") nc = nc + 1)
    when(axlDBCreateVia("VIA10_20-FBD" list(2441.346 1489.236) "PM_L11_EN_L") nv = nv + 1)
    when(axlDBCreatePath(axlPathStart(list(list(2421.661 1469.551) list(2441.346 1489.236)) 5.000) "ETCH/TOP" "PM_L11_EN_L") nc = nc + 1)
    when(axlDBCreatePath(axlPathStart(list(list(2683.177 1489.534) list(2667.177 1489.534)) 5.000) "ETCH/BOTTOM" "PM_L11_EN_L") nc = nc + 1)
    when(axlDBCreatePath(axlPathStart(list(list(2667.177 1489.534) list(2610.343 1432.700)) 5.000) "ETCH/BOTTOM" "PM_L11_EN_L") nc = nc + 1)
    when(axlDBCreatePath(axlPathStart(list(list(2610.343 1432.700) list(2468.551 1432.700)) 5.000) "ETCH/BOTTOM" "PM_L11_EN_L") nc = nc + 1)
    when(axlDBCreatePath(axlPathStart(list(list(2468.551 1432.700) list(2463.551 1437.700)) 5.000) "ETCH/BOTTOM" "PM_L11_EN_L") nc = nc + 1)
    when(axlDBCreatePath(axlPathStart(list(list(2463.551 1437.700) list(2463.551 1467.031)) 5.000) "ETCH/BOTTOM" "PM_L11_EN_L") nc = nc + 1)
    when(axlDBCreatePath(axlPathStart(list(list(2463.551 1467.031) list(2441.346 1489.236)) 5.000) "ETCH/BOTTOM" "PM_L11_EN_L") nc = nc + 1)
    when(axlDBCreatePath(axlPathStart(list(list(2224.151 1390.780) list(2224.151 1391.471)) 12.000) "ETCH/BOTTOM" "0.95VDDC") nc = nc + 1)
    when(axlDBCreatePath(axlPathStart(list(list(2224.151 1391.471) list(2205.126 1410.496)) 12.000) "ETCH/BOTTOM" "0.95VDDC") nc = nc + 1)
    when(axlDBCreatePath(axlPathStart(list(list(2186.151 1430.140) list(2186.151 1429.471)) 12.000) "ETCH/BOTTOM" "0.95VDDC") nc = nc + 1)
    when(axlDBCreatePath(axlPathStart(list(list(2186.151 1429.471) list(2205.126 1410.496)) 12.000) "ETCH/BOTTOM" "0.95VDDC") nc = nc + 1)
    when(axlDBCreatePath(axlPathStart(list(list(2224.151 1390.780) list(2224.842 1390.780)) 12.000) "ETCH/BOTTOM" "0.95VDDC") nc = nc + 1)
    when(axlDBCreatePath(axlPathStart(list(list(2224.842 1390.780) list(2244.496 1371.126)) 12.000) "ETCH/BOTTOM" "0.95VDDC") nc = nc + 1)
    when(axlDBCreateVia("VIA10_20-FBD" list(2244.496 1371.126) "0.95VDDC") nv = nv + 1)
    when(axlDBCreatePath(axlPathStart(list(list(2264.181 1390.811) list(2244.496 1371.126)) 12.000) "ETCH/TOP" "0.95VDDC") nc = nc + 1)
    when(axlDBCreateVia("VIA10_20-FBD" list(2205.126 1410.496) "0.95VDDC") nv = nv + 1)
    when(axlDBCreatePath(axlPathStart(list(list(2224.811 1430.181) list(2205.126 1410.496)) 12.000) "ETCH/TOP" "0.95VDDC") nc = nc + 1)
    when(axlDBCreateVia("VIA10_20-FBD" list(2448.240 1733.011) "0.95VDDC") nv = nv + 1)
    when(axlDBCreatePath(axlPathStart(list(list(2448.240 1762.700) list(2448.240 1733.011)) 12.000) "ETCH/BOTTOM" "0.95VDDC") nc = nc + 1)
    when(axlDBCreatePath(axlPathStart(list(list(2688.551 1387.700) list(2683.551 1387.700)) 12.000) "ETCH/BOTTOM" "0.95VDDC") nc = nc + 1)
    when(axlDBCreatePath(axlPathStart(list(list(2683.551 1387.700) list(2678.240 1382.389)) 12.000) "ETCH/BOTTOM" "0.95VDDC") nc = nc + 1)
    when(axlDBCreatePath(axlPathStart(list(list(2678.240 1382.389) list(2658.551 1382.389)) 12.000) "ETCH/BOTTOM" "0.95VDDC") nc = nc + 1)
    when(axlDBCreateVia("VIA10_20-FBD" list(2688.551 1387.700) "0.95VDDC") nv = nv + 1)
    when(axlDBCreateVia("VIA10_20-FBD" list(2572.929 1793.011) "0.95VDDC") nv = nv + 1)
    when(axlDBCreatePath(axlPathStart(list(list(2603.551 1793.011) list(2572.929 1793.011)) 12.000) "ETCH/BOTTOM" "0.95VDDC") nc = nc + 1)
    when(axlDBCreatePath(axlPathStart(list(list(2224.151 1548.220) list(2224.151 1547.631)) 12.000) "ETCH/BOTTOM" "0.95VDDC") nc = nc + 1)
    when(axlDBCreatePath(axlPathStart(list(list(2224.151 1547.631) list(2205.126 1528.606)) 12.000) "ETCH/BOTTOM" "0.95VDDC") nc = nc + 1)
    when(axlDBCreatePath(axlPathStart(list(list(2225.511 1508.860) list(2224.872 1508.860)) 12.000) "ETCH/BOTTOM" "0.95VDDC") nc = nc + 1)
    when(axlDBCreatePath(axlPathStart(list(list(2224.872 1508.860) list(2205.126 1528.606)) 12.000) "ETCH/BOTTOM" "0.95VDDC") nc = nc + 1)
    when(axlDBCreatePath(axlPathStart(list(list(2224.811 1508.921) list(2205.126 1528.606)) 12.000) "ETCH/TOP" "0.95VDDC") nc = nc + 1)
    when(axlDBCreateVia("VIA10_20-FBD" list(2205.126 1528.606) "0.95VDDC") nv = nv + 1)
    when(axlDBCreatePath(axlPathStart(list(list(2263.511 1469.500) list(2263.511 1470.221)) 12.000) "ETCH/BOTTOM" "0.95VDDC") nc = nc + 1)
    when(axlDBCreatePath(axlPathStart(list(list(2263.511 1470.221) list(2244.496 1489.236)) 12.000) "ETCH/BOTTOM" "0.95VDDC") nc = nc + 1)
    when(axlDBCreatePath(axlPathStart(list(list(2264.181 1469.551) list(2244.496 1489.236)) 12.000) "ETCH/TOP" "0.95VDDC") nc = nc + 1)
    when(axlDBCreateVia("VIA10_20-FBD" list(2244.496 1489.236) "0.95VDDC") nv = nv + 1)
    when(axlDBCreateVia("VIA10_20-FBD" list(2323.236 1528.606) "0.95VDDC") nv = nv + 1)
    when(axlDBCreatePath(axlPathStart(list(list(2303.551 1508.921) list(2323.236 1528.606)) 12.000) "ETCH/TOP" "0.95VDDC") nc = nc + 1)
    when(axlDBCreatePath(axlPathStart(list(list(2302.871 1548.220) list(2303.622 1548.220)) 12.000) "ETCH/BOTTOM" "0.95VDDC") nc = nc + 1)
    when(axlDBCreatePath(axlPathStart(list(list(2303.622 1548.220) list(2323.236 1528.606)) 12.000) "ETCH/BOTTOM" "0.95VDDC") nc = nc + 1)
    when(axlDBCreatePath(axlPathStart(list(list(2304.231 1508.860) list(2304.231 1509.601)) 12.000) "ETCH/BOTTOM" "0.95VDDC") nc = nc + 1)
    when(axlDBCreatePath(axlPathStart(list(list(2304.231 1509.601) list(2323.236 1528.606)) 12.000) "ETCH/BOTTOM" "0.95VDDC") nc = nc + 1)
    when(axlDBCreatePath(axlPathStart(list(list(2342.921 1390.811) list(2323.220 1371.110)) 12.000) "ETCH/TOP" "0.95VDDC") nc = nc + 1)
    when(axlDBCreateVia("VIA10_20-FBD" list(2323.220 1371.110) "0.95VDDC") nv = nv + 1)
    when(axlDBCreatePath(axlPathStart(list(list(2302.871 1390.780) list(2303.550 1390.780)) 12.000) "ETCH/BOTTOM" "0.95VDDC") nc = nc + 1)
    when(axlDBCreatePath(axlPathStart(list(list(2303.550 1390.780) list(2323.220 1371.110)) 12.000) "ETCH/BOTTOM" "0.95VDDC") nc = nc + 1)
    when(axlDBCreatePath(axlPathStart(list(list(2342.231 1469.500) list(2342.870 1469.500)) 12.000) "ETCH/BOTTOM" "0.95VDDC") nc = nc + 1)
    when(axlDBCreatePath(axlPathStart(list(list(2342.870 1469.500) list(2362.606 1489.236)) 12.000) "ETCH/BOTTOM" "0.95VDDC") nc = nc + 1)
    when(axlDBCreatePath(axlPathStart(list(list(2342.921 1469.551) list(2362.606 1489.236)) 12.000) "ETCH/TOP" "0.95VDDC") nc = nc + 1)
    when(axlDBCreateVia("VIA10_20-FBD" list(2362.606 1489.236) "0.95VDDC") nv = nv + 1)
    when(axlDBCreateVia("VIA10_20-FBD" list(2283.850 1410.480) "0.95VDDC") nv = nv + 1)
    when(axlDBCreatePath(axlPathStart(list(list(2303.551 1430.181) list(2283.850 1410.480)) 12.000) "ETCH/TOP" "0.95VDDC") nc = nc + 1)
    when(axlDBCreatePath(axlPathStart(list(list(2264.871 1430.140) list(2264.871 1429.459)) 12.000) "ETCH/BOTTOM" "0.95VDDC") nc = nc + 1)
    when(axlDBCreatePath(axlPathStart(list(list(2264.871 1429.459) list(2283.850 1410.480)) 12.000) "ETCH/BOTTOM" "0.95VDDC") nc = nc + 1)
    when(axlDBCreatePath(axlPathStart(list(list(2702.343 1462.700) list(2683.177 1443.534)) 5.000) "ETCH/BOTTOM" "HOT_PLUG_EN_L") nc = nc + 1)
    when(axlDBCreatePath(axlPathStart(list(list(2683.177 1443.534) list(2683.177 1439.534)) 5.000) "ETCH/BOTTOM" "HOT_PLUG_EN_L") nc = nc + 1)
    when(axlDBCreatePath(axlPathStart(list(list(2683.177 1439.534) list(2650.385 1439.534)) 5.000) "ETCH/BOTTOM" "HOT_PLUG_EN_L") nc = nc + 1)
    when(axlDBCreatePath(axlPathStart(list(list(2650.385 1439.534) list(2618.551 1407.700)) 5.000) "ETCH/BOTTOM" "HOT_PLUG_EN_L") nc = nc + 1)
    when(axlDBCreatePath(axlPathStart(list(list(2618.551 1407.700) list(2468.552 1407.700)) 5.000) "ETCH/BOTTOM" "HOT_PLUG_EN_L") nc = nc + 1)
    when(axlDBCreatePath(axlPathStart(list(list(2468.552 1407.700) list(2452.903 1423.349)) 5.000) "ETCH/BOTTOM" "HOT_PLUG_EN_L") nc = nc + 1)
    when(axlDBCreatePath(axlPathStart(list(list(2452.903 1423.349) list(2452.903 1438.229)) 5.000) "ETCH/BOTTOM" "HOT_PLUG_EN_L") nc = nc + 1)
    when(axlDBCreatePath(axlPathStart(list(list(2452.903 1438.229) list(2441.306 1449.826)) 5.000) "ETCH/BOTTOM" "HOT_PLUG_EN_L") nc = nc + 1)
    when(axlDBCreateVia("VIA10_20-FBD" list(2441.306 1449.826) "HOT_PLUG_EN_L") nv = nv + 1)
    when(axlDBCreatePath(axlPathStart(list(list(2421.661 1430.181) list(2441.306 1449.826)) 5.000) "ETCH/TOP" "HOT_PLUG_EN_L") nc = nc + 1)
    when(axlDBCreatePath(axlPathStart(list(list(2421.661 1312.071) list(2441.332 1292.400)) 12.000) "ETCH/TOP" "1.8VDDR") nc = nc + 1)
    when(axlDBCreateVia("VIA10_20-FBD" list(2441.332 1292.400) "1.8VDDR") nv = nv + 1)
    when(axlDBCreatePath(axlPathStart(list(list(2420.951 1312.060) list(2421.672 1312.060)) 12.000) "ETCH/BOTTOM" "1.8VDDR") nc = nc + 1)
    when(axlDBCreatePath(axlPathStart(list(list(2421.672 1312.060) list(2441.332 1292.400)) 12.000) "ETCH/BOTTOM" "1.8VDDR") nc = nc + 1)
    when(axlDBCreatePath(axlPathStart(list(list(2420.951 1272.700) list(2440.651 1292.400)) 12.000) "ETCH/BOTTOM" "1.8VDDR") nc = nc + 1)
    when(axlDBCreatePath(axlPathStart(list(list(2440.651 1292.400) list(2441.332 1292.400)) 12.000) "ETCH/BOTTOM" "1.8VDDR") nc = nc + 1)
    when(axlDBCreatePath(axlPathStart(list(list(2420.951 1587.580) list(2421.580 1587.580)) 12.000) "ETCH/BOTTOM" "1.8VDDR") nc = nc + 1)
    when(axlDBCreatePath(axlPathStart(list(list(2421.580 1587.580) list(2441.346 1607.346)) 12.000) "ETCH/BOTTOM" "1.8VDDR") nc = nc + 1)
    when(axlDBCreatePath(axlPathStart(list(list(2420.951 1626.940) list(2421.752 1626.940)) 12.000) "ETCH/BOTTOM" "1.8VDDR") nc = nc + 1)
    when(axlDBCreatePath(axlPathStart(list(list(2421.752 1626.940) list(2441.346 1607.346)) 12.000) "ETCH/BOTTOM" "1.8VDDR") nc = nc + 1)
    when(axlDBCreateVia("VIA10_20-FBD" list(2441.346 1607.346) "1.8VDDR") nv = nv + 1)
    when(axlDBCreatePath(axlPathStart(list(list(2421.661 1587.661) list(2441.346 1607.346)) 12.000) "ETCH/TOP" "1.8VDDR") nc = nc + 1)
    when(axlDBCreatePath(axlPathStart(list(list(2106.071 1626.940) list(2106.792 1626.940)) 12.000) "ETCH/BOTTOM" "1.8VDDR") nc = nc + 1)
    when(axlDBCreatePath(axlPathStart(list(list(2106.792 1626.940) list(2126.386 1607.346)) 12.000) "ETCH/BOTTOM" "1.8VDDR") nc = nc + 1)
    when(axlDBCreatePath(axlPathStart(list(list(2106.751 1586.900) list(2106.751 1587.711)) 12.000) "ETCH/BOTTOM" "1.8VDDR") nc = nc + 1)
    when(axlDBCreatePath(axlPathStart(list(list(2106.751 1587.711) list(2126.386 1607.346)) 12.000) "ETCH/BOTTOM" "1.8VDDR") nc = nc + 1)
    when(axlDBCreatePath(axlPathStart(list(list(2146.071 1587.661) list(2126.386 1607.346)) 12.000) "ETCH/TOP" "1.8VDDR") nc = nc + 1)
    when(axlDBCreateVia("VIA10_20-FBD" list(2126.386 1607.346) "1.8VDDR") nv = nv + 1)
    when(axlDBCreatePath(axlPathStart(list(list(2106.751 1352.100) list(2106.751 1351.391)) 12.000) "ETCH/BOTTOM" "1.8VDDR") nc = nc + 1)
    when(axlDBCreatePath(axlPathStart(list(list(2106.751 1351.391) list(2126.416 1331.726)) 12.000) "ETCH/BOTTOM" "1.8VDDR") nc = nc + 1)
    when(axlDBCreatePath(axlPathStart(list(list(2106.071 1312.060) list(2106.750 1312.060)) 12.000) "ETCH/BOTTOM" "1.8VDDR") nc = nc + 1)
    when(axlDBCreatePath(axlPathStart(list(list(2106.750 1312.060) list(2126.416 1331.726)) 12.000) "ETCH/BOTTOM" "1.8VDDR") nc = nc + 1)
    when(axlDBCreatePath(axlPathStart(list(list(2146.071 1312.071) list(2126.416 1331.726)) 12.000) "ETCH/TOP" "1.8VDDR") nc = nc + 1)
    when(axlDBCreateVia("VIA10_20-FBD" list(2126.416 1331.726) "1.8VDDR") nv = nv + 1)
    when(axlDBCreateVia("VIA10_20-FBD" list(2401.951 1174.300) "1.8C_VDDR") nv = nv + 1)
    when(axlDBCreatePath(axlPathStart(list(list(2382.291 1193.960) list(2401.951 1174.300)) 12.000) "ETCH/TOP" "1.8C_VDDR") nc = nc + 1)
    when(axlDBCreatePath(axlPathStart(list(list(2382.271 1155.300) list(2382.951 1155.300)) 12.000) "ETCH/BOTTOM" "1.8C_VDDR") nc = nc + 1)
    when(axlDBCreatePath(axlPathStart(list(list(2382.951 1155.300) list(2401.951 1174.300)) 12.000) "ETCH/BOTTOM" "1.8C_VDDR") nc = nc + 1)
    when(axlDBCreatePath(axlPathStart(list(list(2421.631 1155.300) list(2420.951 1155.300)) 12.000) "ETCH/BOTTOM" "1.8C_VDDR") nc = nc + 1)
    when(axlDBCreatePath(axlPathStart(list(list(2420.951 1155.300) list(2401.951 1174.300)) 12.000) "ETCH/BOTTOM" "1.8C_VDDR") nc = nc + 1)
    when(axlDBCreatePath(axlPathStart(list(list(2224.831 1272.020) list(2224.831 1272.721)) 12.000) "ETCH/BOTTOM" "1.8VPH") nc = nc + 1)
    when(axlDBCreatePath(axlPathStart(list(list(2224.831 1272.721) list(2244.500 1292.390)) 12.000) "ETCH/BOTTOM" "1.8VPH") nc = nc + 1)
    when(axlDBCreatePath(axlPathStart(list(list(2224.831 1312.740) list(2224.831 1312.059)) 12.000) "ETCH/BOTTOM" "1.8VPH") nc = nc + 1)
    when(axlDBCreatePath(axlPathStart(list(list(2224.831 1312.059) list(2244.500 1292.390)) 12.000) "ETCH/BOTTOM" "1.8VPH") nc = nc + 1)
    when(axlDBCreatePath(axlPathStart(list(list(2264.181 1312.071) list(2244.500 1292.390)) 12.000) "ETCH/TOP" "1.8VPH") nc = nc + 1)
    when(axlDBCreateVia("VIA10_20-FBD" list(2244.500 1292.390) "1.8VPH") nv = nv + 1)
    when(axlDBCreateVia("VIA10_20-FBD" list(2244.511 1607.260) "1.8VPH") nv = nv + 1)
    when(axlDBCreatePath(axlPathStart(list(list(2264.181 1587.661) list(2244.582 1607.260)) 12.000) "ETCH/TOP" "1.8VPH") nc = nc + 1)
    when(axlDBCreatePath(axlPathStart(list(list(2244.582 1607.260) list(2244.511 1607.260)) 12.000) "ETCH/TOP" "1.8VPH") nc = nc + 1)
    when(axlDBCreatePath(axlPathStart(list(list(2224.831 1588.260) list(2225.511 1588.260)) 12.000) "ETCH/BOTTOM" "1.8VPH") nc = nc + 1)
    when(axlDBCreatePath(axlPathStart(list(list(2225.511 1588.260) list(2244.511 1607.260)) 12.000) "ETCH/BOTTOM" "1.8VPH") nc = nc + 1)
    when(axlDBCreatePath(axlPathStart(list(list(2264.191 1588.260) list(2263.511 1588.260)) 12.000) "ETCH/BOTTOM" "1.8VPH") nc = nc + 1)
    when(axlDBCreatePath(axlPathStart(list(list(2263.511 1588.260) list(2244.511 1607.260)) 12.000) "ETCH/BOTTOM" "1.8VPH") nc = nc + 1)
    when(axlDBCreatePath(axlPathStart(list(list(2421.631 1352.100) list(2421.631 1351.419)) 12.000) "ETCH/BOTTOM" "0.95C_VDDC") nc = nc + 1)
    when(axlDBCreatePath(axlPathStart(list(list(2421.631 1351.419) list(2401.972 1331.760)) 12.000) "ETCH/BOTTOM" "0.95C_VDDC") nc = nc + 1)
    when(axlDBCreatePath(axlPathStart(list(list(2381.591 1351.420) list(2382.312 1351.420)) 12.000) "ETCH/BOTTOM" "0.95C_VDDC") nc = nc + 1)
    when(axlDBCreatePath(axlPathStart(list(list(2382.312 1351.420) list(2401.972 1331.760)) 12.000) "ETCH/BOTTOM" "0.95C_VDDC") nc = nc + 1)
    when(axlDBCreatePath(axlPathStart(list(list(2382.291 1351.441) list(2401.972 1331.760)) 12.000) "ETCH/TOP" "0.95C_VDDC") nc = nc + 1)
    when(axlDBCreateVia("VIA10_20-FBD" list(2401.972 1331.760) "0.95C_VDDC") nv = nv + 1)
    when(axlDBCreateVia("VIA10_20-FBD" list(2087.056 1371.086) "CKMODE") nv = nv + 1)
    when(axlDBCreatePath(axlPathStart(list(list(2106.701 1351.441) list(2087.056 1371.086)) 5.000) "ETCH/TOP" "CKMODE") nc = nc + 1)
    when(axlDBCreateVia("VIA10_20-FBD" list(2480.716 1607.346) "CLKBUF_INPUT_SEL") nv = nv + 1)
    when(axlDBCreatePath(axlPathStart(list(list(2461.031 1587.661) list(2480.716 1607.346)) 5.000) "ETCH/TOP" "CLKBUF_INPUT_SEL") nc = nc + 1)
    when(axlDBCreatePath(axlPathStart(list(list(2576.551 1677.700) list(2526.551 1627.700)) 5.000) "ETCH/BOTTOM" "CLKBUF_INPUT_SEL") nc = nc + 1)
    when(axlDBCreatePath(axlPathStart(list(list(2526.551 1627.700) list(2501.070 1627.700)) 5.000) "ETCH/BOTTOM" "CLKBUF_INPUT_SEL") nc = nc + 1)
    when(axlDBCreatePath(axlPathStart(list(list(2501.070 1627.700) list(2480.716 1607.346)) 5.000) "ETCH/BOTTOM" "CLKBUF_INPUT_SEL") nc = nc + 1)
    when(axlDBCreatePath(axlPathStart(list(list(2143.551 1309.551) list(2165.756 1331.756)) 5.400) "ETCH/BOTTOM" "PETP0_RECEPT") nc = nc + 1)
    when(axlDBCreateVia("VIA10_20-FBD" list(2165.756 1331.756) "PETP0_RECEPT") nv = nv + 1)
    when(axlDBCreatePath(axlPathStart(list(list(2185.441 1351.441) list(2165.756 1331.756)) 5.000) "ETCH/TOP" "PETP0_RECEPT") nc = nc + 1)
    when(axlDBCreatePath(axlPathStart(list(list(2154.551 1028.577) list(2154.551 1041.177)) 5.400) "ETCH/BOTTOM" "PETN0_RECEPT") nc = nc + 1)
    when(axlDBCreatePath(axlPathStart(list(list(2154.551 1041.177) list(2163.551 1050.177)) 5.400) "ETCH/BOTTOM" "PETN0_RECEPT") nc = nc + 1)
    when(axlDBCreatePath(axlPathStart(list(list(2163.551 1050.177) list(2163.551 1062.777)) 5.400) "ETCH/BOTTOM" "PETN0_RECEPT") nc = nc + 1)
    when(axlDBCreatePath(axlPathStart(list(list(2163.551 1062.777) list(2154.551 1071.777)) 5.400) "ETCH/BOTTOM" "PETN0_RECEPT") nc = nc + 1)
    when(axlDBCreatePath(axlPathStart(list(list(2154.551 1071.777) list(2154.551 1281.181)) 5.400) "ETCH/BOTTOM" "PETN0_RECEPT") nc = nc + 1)
    when(axlDBCreatePath(axlPathStart(list(list(2154.551 1281.181) list(2165.756 1292.386)) 5.400) "ETCH/BOTTOM" "PETN0_RECEPT") nc = nc + 1)
    when(axlDBCreateVia("VIA10_20-FBD" list(2165.756 1292.386) "PETN0_RECEPT") nv = nv + 1)
    when(axlDBCreatePath(axlPathStart(list(list(2185.441 1312.071) list(2165.756 1292.386)) 5.000) "ETCH/TOP" "PETN0_RECEPT") nc = nc + 1)
    when(axlDBCreatePath(axlPathStart(list(list(2185.441 1233.331) list(2166.551 1214.441)) 5.400) "ETCH/TOP" "PERP0_RECEPT") nc = nc + 1)
    when(axlDBCreatePath(axlPathStart(list(list(2166.551 1214.441) list(2166.551 1181.227)) 5.400) "ETCH/TOP" "PERP0_RECEPT") nc = nc + 1)
    when(axlDBCreatePath(axlPathStart(list(list(2166.551 1181.227) list(2102.551 1117.227)) 5.400) "ETCH/TOP" "PERP0_RECEPT") nc = nc + 1)
    when(axlDBCreatePath(axlPathStart(list(list(2113.551 1026.470) list(2121.551 1034.470)) 5.400) "ETCH/TOP" "PERN0_RECEPT") nc = nc + 1)
    when(axlDBCreatePath(axlPathStart(list(list(2121.551 1034.470) list(2121.551 1050.070)) 5.400) "ETCH/TOP" "PERN0_RECEPT") nc = nc + 1)
    when(axlDBCreatePath(axlPathStart(list(list(2121.551 1050.070) list(2113.551 1058.070)) 5.400) "ETCH/TOP" "PERN0_RECEPT") nc = nc + 1)
    when(axlDBCreatePath(axlPathStart(list(list(2113.551 1058.070) list(2113.551 1069.670)) 5.400) "ETCH/TOP" "PERN0_RECEPT") nc = nc + 1)
    when(axlDBCreatePath(axlPathStart(list(list(2113.551 1069.670) list(2121.551 1077.670)) 5.400) "ETCH/TOP" "PERN0_RECEPT") nc = nc + 1)
    when(axlDBCreatePath(axlPathStart(list(list(2121.551 1077.670) list(2121.551 1093.270)) 5.400) "ETCH/TOP" "PERN0_RECEPT") nc = nc + 1)
    when(axlDBCreatePath(axlPathStart(list(list(2121.551 1093.270) list(2113.551 1101.270)) 5.400) "ETCH/TOP" "PERN0_RECEPT") nc = nc + 1)
    when(axlDBCreatePath(axlPathStart(list(list(2113.551 1101.270) list(2113.551 1112.670)) 5.400) "ETCH/TOP" "PERN0_RECEPT") nc = nc + 1)
    when(axlDBCreatePath(axlPathStart(list(list(2113.551 1112.670) list(2124.355 1123.474)) 5.400) "ETCH/TOP" "PERN0_RECEPT") nc = nc + 1)
    when(axlDBCreatePath(axlPathStart(list(list(2124.355 1123.474) list(2136.325 1123.474)) 5.400) "ETCH/TOP" "PERN0_RECEPT") nc = nc + 1)
    when(axlDBCreatePath(axlPathStart(list(list(2136.325 1123.474) list(2145.114 1132.263)) 5.400) "ETCH/TOP" "PERN0_RECEPT") nc = nc + 1)
    when(axlDBCreatePath(axlPathStart(list(list(2145.114 1132.263) list(2145.114 1144.233)) 5.400) "ETCH/TOP" "PERN0_RECEPT") nc = nc + 1)
    when(axlDBCreatePath(axlPathStart(list(list(2145.114 1144.233) list(2154.903 1154.022)) 5.400) "ETCH/TOP" "PERN0_RECEPT") nc = nc + 1)
    when(axlDBCreatePath(axlPathStart(list(list(2154.903 1154.022) list(2169.873 1154.022)) 5.400) "ETCH/TOP" "PERN0_RECEPT") nc = nc + 1)
    when(axlDBCreatePath(axlPathStart(list(list(2169.873 1154.022) list(2177.551 1161.700)) 5.400) "ETCH/TOP" "PERN0_RECEPT") nc = nc + 1)
    when(axlDBCreatePath(axlPathStart(list(list(2177.551 1161.700) list(2177.551 1186.070)) 5.400) "ETCH/TOP" "PERN0_RECEPT") nc = nc + 1)
    when(axlDBCreatePath(axlPathStart(list(list(2177.551 1186.070) list(2185.441 1193.960)) 5.400) "ETCH/TOP" "PERN0_RECEPT") nc = nc + 1)
    when(axlDBCreatePath(axlPathStart(list(list(2175.551 1095.699) list(2175.551 1266.257)) 5.400) "ETCH/BOTTOM" "PETP1_RECEPT") nc = nc + 1)
    when(axlDBCreatePath(axlPathStart(list(list(2175.551 1266.257) list(2183.551 1274.257)) 5.400) "ETCH/BOTTOM" "PETP1_RECEPT") nc = nc + 1)
    when(axlDBCreatePath(axlPathStart(list(list(2183.551 1274.257) list(2183.551 1310.181)) 5.400) "ETCH/BOTTOM" "PETP1_RECEPT") nc = nc + 1)
    when(axlDBCreatePath(axlPathStart(list(list(2183.551 1310.181) list(2205.126 1331.756)) 5.400) "ETCH/BOTTOM" "PETP1_RECEPT") nc = nc + 1)
    when(axlDBCreateVia("VIA10_20-FBD" list(2205.126 1331.756) "PETP1_RECEPT") nv = nv + 1)
    when(axlDBCreatePath(axlPathStart(list(list(2224.811 1351.441) list(2205.126 1331.756)) 5.000) "ETCH/TOP" "PETP1_RECEPT") nc = nc + 1)
    when(axlDBCreatePath(axlPathStart(list(list(2274.398 1024.853) list(2261.954 1024.853)) 5.400) "ETCH/BOTTOM" "PETN1_RECEPT") nc = nc + 1)
    when(axlDBCreatePath(axlPathStart(list(list(2261.954 1024.853) list(2252.902 1033.905)) 5.400) "ETCH/BOTTOM" "PETN1_RECEPT") nc = nc + 1)
    when(axlDBCreatePath(axlPathStart(list(list(2252.902 1033.905) list(2252.902 1046.349)) 5.400) "ETCH/BOTTOM" "PETN1_RECEPT") nc = nc + 1)
    when(axlDBCreatePath(axlPathStart(list(list(2252.902 1046.349) list(2243.850 1055.401)) 5.400) "ETCH/BOTTOM" "PETN1_RECEPT") nc = nc + 1)
    when(axlDBCreatePath(axlPathStart(list(list(2243.850 1055.401) list(2231.406 1055.401)) 5.400) "ETCH/BOTTOM" "PETN1_RECEPT") nc = nc + 1)
    when(axlDBCreatePath(axlPathStart(list(list(2231.406 1055.401) list(2222.354 1064.453)) 5.400) "ETCH/BOTTOM" "PETN1_RECEPT") nc = nc + 1)
    when(axlDBCreatePath(axlPathStart(list(list(2222.354 1064.453) list(2222.354 1076.897)) 5.400) "ETCH/BOTTOM" "PETN1_RECEPT") nc = nc + 1)
    when(axlDBCreatePath(axlPathStart(list(list(2222.354 1076.897) list(2213.302 1085.949)) 5.400) "ETCH/BOTTOM" "PETN1_RECEPT") nc = nc + 1)
    when(axlDBCreatePath(axlPathStart(list(list(2213.302 1085.949) list(2200.858 1085.949)) 5.400) "ETCH/BOTTOM" "PETN1_RECEPT") nc = nc + 1)
    when(axlDBCreatePath(axlPathStart(list(list(2200.858 1085.949) list(2186.551 1100.256)) 5.400) "ETCH/BOTTOM" "PETN1_RECEPT") nc = nc + 1)
    when(axlDBCreatePath(axlPathStart(list(list(2186.551 1100.256) list(2186.551 1111.656)) 5.400) "ETCH/BOTTOM" "PETN1_RECEPT") nc = nc + 1)
    when(axlDBCreatePath(axlPathStart(list(list(2186.551 1111.656) list(2195.551 1120.656)) 5.400) "ETCH/BOTTOM" "PETN1_RECEPT") nc = nc + 1)
    when(axlDBCreatePath(axlPathStart(list(list(2195.551 1120.656) list(2195.551 1133.256)) 5.400) "ETCH/BOTTOM" "PETN1_RECEPT") nc = nc + 1)
    when(axlDBCreatePath(axlPathStart(list(list(2195.551 1133.256) list(2186.551 1142.256)) 5.400) "ETCH/BOTTOM" "PETN1_RECEPT") nc = nc + 1)
    when(axlDBCreatePath(axlPathStart(list(list(2186.551 1142.256) list(2186.551 1154.856)) 5.400) "ETCH/BOTTOM" "PETN1_RECEPT") nc = nc + 1)
    when(axlDBCreatePath(axlPathStart(list(list(2186.551 1154.856) list(2195.551 1163.856)) 5.400) "ETCH/BOTTOM" "PETN1_RECEPT") nc = nc + 1)
    when(axlDBCreatePath(axlPathStart(list(list(2195.551 1163.856) list(2195.551 1176.456)) 5.400) "ETCH/BOTTOM" "PETN1_RECEPT") nc = nc + 1)
    when(axlDBCreatePath(axlPathStart(list(list(2195.551 1176.456) list(2186.551 1185.456)) 5.400) "ETCH/BOTTOM" "PETN1_RECEPT") nc = nc + 1)
    when(axlDBCreatePath(axlPathStart(list(list(2186.551 1185.456) list(2186.551 1198.056)) 5.400) "ETCH/BOTTOM" "PETN1_RECEPT") nc = nc + 1)
    when(axlDBCreatePath(axlPathStart(list(list(2186.551 1198.056) list(2195.551 1207.056)) 5.400) "ETCH/BOTTOM" "PETN1_RECEPT") nc = nc + 1)
    when(axlDBCreatePath(axlPathStart(list(list(2195.551 1207.056) list(2195.551 1219.656)) 5.400) "ETCH/BOTTOM" "PETN1_RECEPT") nc = nc + 1)
    when(axlDBCreatePath(axlPathStart(list(list(2195.551 1219.656) list(2186.551 1228.656)) 5.400) "ETCH/BOTTOM" "PETN1_RECEPT") nc = nc + 1)
    when(axlDBCreatePath(axlPathStart(list(list(2186.551 1228.656) list(2186.551 1261.700)) 5.400) "ETCH/BOTTOM" "PETN1_RECEPT") nc = nc + 1)
    when(axlDBCreatePath(axlPathStart(list(list(2186.551 1261.700) list(2205.126 1280.275)) 5.400) "ETCH/BOTTOM" "PETN1_RECEPT") nc = nc + 1)
    when(axlDBCreatePath(axlPathStart(list(list(2205.126 1280.275) list(2205.126 1292.386)) 5.400) "ETCH/BOTTOM" "PETN1_RECEPT") nc = nc + 1)
    when(axlDBCreateVia("VIA10_20-FBD" list(2205.126 1292.386) "PETN1_RECEPT") nv = nv + 1)
    when(axlDBCreatePath(axlPathStart(list(list(2224.811 1312.071) list(2205.126 1292.386)) 5.000) "ETCH/TOP" "PETN1_RECEPT") nc = nc + 1)
    when(axlDBCreatePath(axlPathStart(list(list(2153.551 1096.700) list(2206.551 1149.700)) 5.400) "ETCH/TOP" "PERP1_RECEPT") nc = nc + 1)
    when(axlDBCreatePath(axlPathStart(list(list(2206.551 1149.700) list(2206.551 1215.071)) 5.400) "ETCH/TOP" "PERP1_RECEPT") nc = nc + 1)
    when(axlDBCreatePath(axlPathStart(list(list(2206.551 1215.071) list(2224.811 1233.331)) 5.400) "ETCH/TOP" "PERP1_RECEPT") nc = nc + 1)
    when(axlDBCreatePath(axlPathStart(list(list(2224.811 1193.960) list(2217.551 1186.700)) 5.400) "ETCH/TOP" "PERN1_RECEPT") nc = nc + 1)
    when(axlDBCreatePath(axlPathStart(list(list(2217.551 1186.700) list(2217.551 1128.047)) 5.400) "ETCH/TOP" "PERN1_RECEPT") nc = nc + 1)
    when(axlDBCreatePath(axlPathStart(list(list(2217.551 1128.047) list(2210.204 1120.700)) 5.400) "ETCH/TOP" "PERN1_RECEPT") nc = nc + 1)
    when(axlDBCreatePath(axlPathStart(list(list(2210.204 1120.700) list(2193.108 1120.700)) 5.400) "ETCH/TOP" "PERN1_RECEPT") nc = nc + 1)
    when(axlDBCreatePath(axlPathStart(list(list(2193.108 1120.700) list(2164.551 1092.143)) 5.400) "ETCH/TOP" "PERN1_RECEPT") nc = nc + 1)
    when(axlDBCreatePath(axlPathStart(list(list(2164.551 1092.143) list(2164.551 1079.015)) 5.400) "ETCH/TOP" "PERN1_RECEPT") nc = nc + 1)
    when(axlDBCreatePath(axlPathStart(list(list(2164.551 1079.015) list(2174.551 1069.015)) 5.400) "ETCH/TOP" "PERN1_RECEPT") nc = nc + 1)
    when(axlDBCreatePath(axlPathStart(list(list(2174.551 1069.015) list(2174.551 1057.415)) 5.400) "ETCH/TOP" "PERN1_RECEPT") nc = nc + 1)
    when(axlDBCreatePath(axlPathStart(list(list(2174.551 1057.415) list(2164.551 1047.415)) 5.400) "ETCH/TOP" "PERN1_RECEPT") nc = nc + 1)
    when(axlDBCreatePath(axlPathStart(list(list(2164.551 1047.415) list(2164.551 1035.815)) 5.400) "ETCH/TOP" "PERN1_RECEPT") nc = nc + 1)
    when(axlDBCreatePath(axlPathStart(list(list(2164.551 1035.815) list(2174.551 1025.815)) 5.400) "ETCH/TOP" "PERN1_RECEPT") nc = nc + 1)
    when(axlDBCreatePath(axlPathStart(list(list(2303.551 1047.699) list(2303.551 1312.070)) 5.400) "ETCH/BOTTOM" "PETP2_RECEPT") nc = nc + 1)
    when(axlDBCreatePath(axlPathStart(list(list(2303.551 1312.070) list(2323.231 1331.750)) 5.400) "ETCH/BOTTOM" "PETP2_RECEPT") nc = nc + 1)
    when(axlDBCreateVia("VIA10_20-FBD" list(2323.231 1331.750) "PETP2_RECEPT") nv = nv + 1)
    when(axlDBCreatePath(axlPathStart(list(list(2303.551 1351.441) list(2323.231 1331.761)) 5.000) "ETCH/TOP" "PETP2_RECEPT") nc = nc + 1)
    when(axlDBCreatePath(axlPathStart(list(list(2323.231 1331.761) list(2323.231 1331.750)) 5.000) "ETCH/TOP" "PETP2_RECEPT") nc = nc + 1)
    when(axlDBCreatePath(axlPathStart(list(list(2314.551 1052.256) list(2314.551 1284.980)) 5.400) "ETCH/BOTTOM" "PETN2_RECEPT") nc = nc + 1)
    when(axlDBCreatePath(axlPathStart(list(list(2314.551 1284.980) list(2321.951 1292.380)) 5.400) "ETCH/BOTTOM" "PETN2_RECEPT") nc = nc + 1)
    when(axlDBCreatePath(axlPathStart(list(list(2321.951 1292.380) list(2323.231 1292.380)) 5.400) "ETCH/BOTTOM" "PETN2_RECEPT") nc = nc + 1)
    when(axlDBCreateVia("VIA10_20-FBD" list(2323.231 1292.380) "PETN2_RECEPT") nv = nv + 1)
    when(axlDBCreatePath(axlPathStart(list(list(2303.551 1312.071) list(2323.231 1292.391)) 5.000) "ETCH/TOP" "PETN2_RECEPT") nc = nc + 1)
    when(axlDBCreatePath(axlPathStart(list(list(2323.231 1292.391) list(2323.231 1292.380)) 5.000) "ETCH/TOP" "PETN2_RECEPT") nc = nc + 1)
    when(axlDBCreatePath(axlPathStart(list(list(2303.551 1233.331) list(2285.291 1215.071)) 5.400) "ETCH/TOP" "PERP2_RECEPT") nc = nc + 1)
    when(axlDBCreateVia("VIA10_20-FBD" list(2165.756 1371.126) "0.95VP") nv = nv + 1)
    when(axlDBCreatePath(axlPathStart(list(list(2185.441 1390.811) list(2165.756 1371.126)) 12.000) "ETCH/TOP" "0.95VP") nc = nc + 1)
    when(axlDBCreatePath(axlPathStart(list(list(2184.791 1351.420) list(2184.791 1352.091)) 12.000) "ETCH/BOTTOM" "0.95VP") nc = nc + 1)
    when(axlDBCreatePath(axlPathStart(list(list(2184.791 1352.091) list(2165.756 1371.126)) 12.000) "ETCH/BOTTOM" "0.95VP") nc = nc + 1)
    when(axlDBCreatePath(axlPathStart(list(list(2146.111 1391.460) list(2146.111 1390.771)) 12.000) "ETCH/BOTTOM" "0.95VP") nc = nc + 1)
    when(axlDBCreatePath(axlPathStart(list(list(2146.111 1390.771) list(2165.756 1371.126)) 12.000) "ETCH/BOTTOM" "0.95VP") nc = nc + 1)
    when(axlDBCreatePath(axlPathStart(list(list(2381.591 1548.220) list(2382.362 1548.220)) 12.000) "ETCH/BOTTOM" "0.95VP") nc = nc + 1)
    when(axlDBCreatePath(axlPathStart(list(list(2382.362 1548.220) list(2401.976 1528.606)) 12.000) "ETCH/BOTTOM" "0.95VP") nc = nc + 1)
    when(axlDBCreatePath(axlPathStart(list(list(2382.271 1508.180) list(2382.271 1508.901)) 12.000) "ETCH/BOTTOM" "0.95VP") nc = nc + 1)
    when(axlDBCreatePath(axlPathStart(list(list(2382.271 1508.901) list(2401.976 1528.606)) 12.000) "ETCH/BOTTOM" "0.95VP") nc = nc + 1)
    when(axlDBCreatePath(axlPathStart(list(list(2382.291 1508.921) list(2401.976 1528.606)) 12.000) "ETCH/TOP" "0.95VP") nc = nc + 1)
    when(axlDBCreateVia("VIA10_20-FBD" list(2401.976 1528.606) "0.95VP") nv = nv + 1)
    when(axlDBCreatePath(axlPathStart(list(list(2146.111 1470.180) list(2146.700 1470.180)) 12.000) "ETCH/BOTTOM" "0.95VP") nc = nc + 1)
    when(axlDBCreatePath(axlPathStart(list(list(2146.700 1470.180) list(2165.756 1489.236)) 12.000) "ETCH/BOTTOM" "0.95VP") nc = nc + 1)
    when(axlDBCreatePath(axlPathStart(list(list(2185.471 1470.180) list(2184.812 1470.180)) 12.000) "ETCH/BOTTOM" "0.95VP") nc = nc + 1)
    when(axlDBCreatePath(axlPathStart(list(list(2184.812 1470.180) list(2165.756 1489.236)) 12.000) "ETCH/BOTTOM" "0.95VP") nc = nc + 1)
    when(axlDBCreatePath(axlPathStart(list(list(2185.441 1469.551) list(2165.756 1489.236)) 12.000) "ETCH/TOP" "0.95VP") nc = nc + 1)
    when(axlDBCreateVia("VIA10_20-FBD" list(2165.756 1489.236) "0.95VP") nv = nv + 1)
    when(axlDBCreatePath(axlPathStart(list(list(2598.551 1382.389) list(2623.240 1382.389)) 12.000) "ETCH/BOTTOM" "0.95VP") nc = nc + 1)
    when(axlDBCreatePath(axlPathStart(list(list(2623.240 1382.389) list(2628.551 1387.700)) 12.000) "ETCH/BOTTOM" "0.95VP") nc = nc + 1)
    when(axlDBCreateVia("VIA10_20-FBD" list(2628.551 1387.700) "0.95VP") nv = nv + 1)
    when(axlDBCreatePath(axlPathStart(list(list(2381.591 1430.140) list(2382.332 1430.140)) 12.000) "ETCH/BOTTOM" "0.95VP") nc = nc + 1)
    when(axlDBCreatePath(axlPathStart(list(list(2382.332 1430.140) list(2401.982 1410.490)) 12.000) "ETCH/BOTTOM" "0.95VP") nc = nc + 1)
    when(axlDBCreatePath(axlPathStart(list(list(2382.291 1430.181) list(2401.982 1410.490)) 12.000) "ETCH/TOP" "0.95VP") nc = nc + 1)
    when(axlDBCreateVia("VIA10_20-FBD" list(2401.982 1410.490) "0.95VP") nv = nv + 1)
    when(axlDBCreatePath(axlPathStart(list(list(2303.551 1193.960) list(2296.291 1186.700)) 5.400) "ETCH/TOP" "PERN2_RECEPT") nc = nc + 1)
    when(axlDBCreatePath(axlPathStart(list(list(2296.291 1186.700) list(2296.291 1170.574)) 5.400) "ETCH/TOP" "PERN2_RECEPT") nc = nc + 1)
    when(axlDBCreatePath(axlPathStart(list(list(2296.291 1170.574) list(2305.551 1161.314)) 5.400) "ETCH/TOP" "PERN2_RECEPT") nc = nc + 1)
    when(axlDBCreatePath(axlPathStart(list(list(2305.551 1161.314) list(2305.551 1148.974)) 5.400) "ETCH/TOP" "PERN2_RECEPT") nc = nc + 1)
    when(axlDBCreatePath(axlPathStart(list(list(2305.551 1148.974) list(2296.291 1139.714)) 5.400) "ETCH/TOP" "PERN2_RECEPT") nc = nc + 1)
    when(axlDBCreatePath(axlPathStart(list(list(2296.291 1139.714) list(2296.291 1127.374)) 5.400) "ETCH/TOP" "PERN2_RECEPT") nc = nc + 1)
    when(axlDBCreatePath(axlPathStart(list(list(2296.291 1127.374) list(2305.551 1118.114)) 5.400) "ETCH/TOP" "PERN2_RECEPT") nc = nc + 1)
    when(axlDBCreatePath(axlPathStart(list(list(2305.551 1118.114) list(2305.551 1105.774)) 5.400) "ETCH/TOP" "PERN2_RECEPT") nc = nc + 1)
    when(axlDBCreatePath(axlPathStart(list(list(2305.551 1105.774) list(2296.291 1096.514)) 5.400) "ETCH/TOP" "PERN2_RECEPT") nc = nc + 1)
    when(axlDBCreatePath(axlPathStart(list(list(2296.291 1096.514) list(2296.291 1084.174)) 5.400) "ETCH/TOP" "PERN2_RECEPT") nc = nc + 1)
    when(axlDBCreatePath(axlPathStart(list(list(2296.291 1084.174) list(2305.551 1074.914)) 5.400) "ETCH/TOP" "PERN2_RECEPT") nc = nc + 1)
    when(axlDBCreatePath(axlPathStart(list(list(2305.551 1074.914) list(2305.551 1062.574)) 5.400) "ETCH/TOP" "PERN2_RECEPT") nc = nc + 1)
    when(axlDBCreatePath(axlPathStart(list(list(2305.551 1062.574) list(2296.291 1053.314)) 5.400) "ETCH/TOP" "PERN2_RECEPT") nc = nc + 1)
    when(axlDBCreatePath(axlPathStart(list(list(2296.291 1053.314) list(2296.291 1040.974)) 5.400) "ETCH/TOP" "PERN2_RECEPT") nc = nc + 1)
    when(axlDBCreatePath(axlPathStart(list(list(2296.291 1040.974) list(2305.551 1031.714)) 5.400) "ETCH/TOP" "PERN2_RECEPT") nc = nc + 1)
    when(axlDBCreatePath(axlPathStart(list(list(2334.551 1078.142) list(2334.551 1274.257)) 5.400) "ETCH/BOTTOM" "PETP3_RECEPT") nc = nc + 1)
    when(axlDBCreatePath(axlPathStart(list(list(2334.551 1274.257) list(2345.551 1285.257)) 5.400) "ETCH/BOTTOM" "PETP3_RECEPT") nc = nc + 1)
    when(axlDBCreatePath(axlPathStart(list(list(2345.551 1285.257) list(2345.551 1314.709)) 5.400) "ETCH/BOTTOM" "PETP3_RECEPT") nc = nc + 1)
    when(axlDBCreatePath(axlPathStart(list(list(2345.551 1314.709) list(2362.602 1331.760)) 5.400) "ETCH/BOTTOM" "PETP3_RECEPT") nc = nc + 1)
    when(axlDBCreateVia("VIA10_20-FBD" list(2362.602 1331.760) "PETP3_RECEPT") nv = nv + 1)
    when(axlDBCreatePath(axlPathStart(list(list(2342.921 1351.441) list(2362.602 1331.760)) 5.000) "ETCH/TOP" "PETP3_RECEPT") nc = nc + 1)
    when(axlDBCreatePath(axlPathStart(list(list(2377.785 1050.465) list(2377.785 1064.465)) 5.400) "ETCH/BOTTOM" "PETN3_RECEPT") nc = nc + 1)
    when(axlDBCreatePath(axlPathStart(list(list(2377.785 1064.465) list(2369.511 1072.739)) 5.400) "ETCH/BOTTOM" "PETN3_RECEPT") nc = nc + 1)
    when(axlDBCreatePath(axlPathStart(list(list(2369.511 1072.739) list(2355.511 1072.739)) 5.400) "ETCH/BOTTOM" "PETN3_RECEPT") nc = nc + 1)
    when(axlDBCreatePath(axlPathStart(list(list(2355.511 1072.739) list(2345.551 1082.699)) 5.400) "ETCH/BOTTOM" "PETN3_RECEPT") nc = nc + 1)
    when(axlDBCreatePath(axlPathStart(list(list(2345.551 1082.699) list(2345.551 1095.233)) 5.400) "ETCH/BOTTOM" "PETN3_RECEPT") nc = nc + 1)
    when(axlDBCreatePath(axlPathStart(list(list(2345.551 1095.233) list(2355.551 1105.233)) 5.400) "ETCH/BOTTOM" "PETN3_RECEPT") nc = nc + 1)
    when(axlDBCreatePath(axlPathStart(list(list(2355.551 1105.233) list(2355.551 1116.833)) 5.400) "ETCH/BOTTOM" "PETN3_RECEPT") nc = nc + 1)
    when(axlDBCreatePath(axlPathStart(list(list(2355.551 1116.833) list(2345.551 1126.833)) 5.400) "ETCH/BOTTOM" "PETN3_RECEPT") nc = nc + 1)
    when(axlDBCreatePath(axlPathStart(list(list(2345.551 1126.833) list(2345.551 1138.433)) 5.400) "ETCH/BOTTOM" "PETN3_RECEPT") nc = nc + 1)
    when(axlDBCreatePath(axlPathStart(list(list(2345.551 1138.433) list(2353.551 1146.433)) 5.400) "ETCH/BOTTOM" "PETN3_RECEPT") nc = nc + 1)
    when(axlDBCreatePath(axlPathStart(list(list(2353.551 1146.433) list(2353.551 1162.033)) 5.400) "ETCH/BOTTOM" "PETN3_RECEPT") nc = nc + 1)
    when(axlDBCreatePath(axlPathStart(list(list(2353.551 1162.033) list(2345.551 1170.033)) 5.400) "ETCH/BOTTOM" "PETN3_RECEPT") nc = nc + 1)
    when(axlDBCreatePath(axlPathStart(list(list(2345.551 1170.033) list(2345.551 1181.633)) 5.400) "ETCH/BOTTOM" "PETN3_RECEPT") nc = nc + 1)
    when(axlDBCreatePath(axlPathStart(list(list(2345.551 1181.633) list(2353.551 1189.633)) 5.400) "ETCH/BOTTOM" "PETN3_RECEPT") nc = nc + 1)
    when(axlDBCreatePath(axlPathStart(list(list(2353.551 1189.633) list(2353.551 1205.233)) 5.400) "ETCH/BOTTOM" "PETN3_RECEPT") nc = nc + 1)
    when(axlDBCreatePath(axlPathStart(list(list(2353.551 1205.233) list(2345.551 1213.233)) 5.400) "ETCH/BOTTOM" "PETN3_RECEPT") nc = nc + 1)
    when(axlDBCreatePath(axlPathStart(list(list(2345.551 1213.233) list(2345.551 1220.700)) 5.400) "ETCH/BOTTOM" "PETN3_RECEPT") nc = nc + 1)
    when(axlDBCreatePath(axlPathStart(list(list(2345.551 1220.700) list(2352.551 1227.700)) 5.400) "ETCH/BOTTOM" "PETN3_RECEPT") nc = nc + 1)
    when(axlDBCreatePath(axlPathStart(list(list(2352.551 1227.700) list(2352.551 1238.700)) 5.400) "ETCH/BOTTOM" "PETN3_RECEPT") nc = nc + 1)
    when(axlDBCreatePath(axlPathStart(list(list(2352.551 1238.700) list(2345.551 1245.700)) 5.400) "ETCH/BOTTOM" "PETN3_RECEPT") nc = nc + 1)
    when(axlDBCreatePath(axlPathStart(list(list(2345.551 1245.700) list(2345.551 1269.700)) 5.400) "ETCH/BOTTOM" "PETN3_RECEPT") nc = nc + 1)
    when(axlDBCreatePath(axlPathStart(list(list(2345.551 1269.700) list(2362.602 1286.751)) 5.400) "ETCH/BOTTOM" "PETN3_RECEPT") nc = nc + 1)
    when(axlDBCreatePath(axlPathStart(list(list(2362.602 1286.751) list(2362.602 1292.390)) 5.400) "ETCH/BOTTOM" "PETN3_RECEPT") nc = nc + 1)
    when(axlDBCreateVia("VIA10_20-FBD" list(2362.602 1292.390) "PETN3_RECEPT") nv = nv + 1)
    when(axlDBCreatePath(axlPathStart(list(list(2342.921 1312.071) list(2362.602 1292.390)) 5.000) "ETCH/TOP" "PETN3_RECEPT") nc = nc + 1)
    when(axlDBCreatePath(axlPathStart(list(list(2342.921 1233.331) list(2364.551 1211.701)) 5.400) "ETCH/TOP" "PERP3_RECEPT") nc = nc + 1)
    when(axlDBCreatePath(axlPathStart(list(list(2342.921 1193.960) list(2353.551 1183.330)) 5.400) "ETCH/TOP" "PERN3_RECEPT") nc = nc + 1)
    when(axlDBCreatePath(axlPathStart(list(list(2353.551 1183.330) list(2353.551 1162.095)) 5.400) "ETCH/TOP" "PERN3_RECEPT") nc = nc + 1)
    when(axlDBCreatePath(axlPathStart(list(list(2353.551 1162.095) list(2345.551 1154.095)) 5.400) "ETCH/TOP" "PERN3_RECEPT") nc = nc + 1)
    when(axlDBCreatePath(axlPathStart(list(list(2345.551 1154.095) list(2345.551 1140.495)) 5.400) "ETCH/TOP" "PERN3_RECEPT") nc = nc + 1)
    when(axlDBCreatePath(axlPathStart(list(list(2345.551 1140.495) list(2353.551 1132.495)) 5.400) "ETCH/TOP" "PERN3_RECEPT") nc = nc + 1)
    when(axlDBCreatePath(axlPathStart(list(list(2332.551 1628.699) list(2343.551 1617.699)) 5.400) "ETCH/BOTTOM" "PETP4_RECEPT") nc = nc + 1)
    when(axlDBCreatePath(axlPathStart(list(list(2343.551 1617.699) list(2343.551 1587.031)) 5.400) "ETCH/BOTTOM" "PETP4_RECEPT") nc = nc + 1)
    when(axlDBCreatePath(axlPathStart(list(list(2343.551 1587.031) list(2362.606 1567.976)) 5.400) "ETCH/BOTTOM" "PETP4_RECEPT") nc = nc + 1)
    when(axlDBCreateVia("VIA10_20-FBD" list(2362.606 1567.976) "PETP4_RECEPT") nv = nv + 1)
    when(axlDBCreatePath(axlPathStart(list(list(2342.921 1548.291) list(2362.606 1567.976)) 5.000) "ETCH/TOP" "PETP4_RECEPT") nc = nc + 1)
    when(axlDBCreatePath(axlPathStart(list(list(2343.551 1865.386) list(2349.551 1859.386)) 5.400) "ETCH/BOTTOM" "PETN4_RECEPT") nc = nc + 1)
    when(axlDBCreatePath(axlPathStart(list(list(2349.551 1859.386) list(2349.551 1839.786)) 5.400) "ETCH/BOTTOM" "PETN4_RECEPT") nc = nc + 1)
    when(axlDBCreatePath(axlPathStart(list(list(2349.551 1839.786) list(2343.551 1833.786)) 5.400) "ETCH/BOTTOM" "PETN4_RECEPT") nc = nc + 1)
    when(axlDBCreatePath(axlPathStart(list(list(2343.551 1833.786) list(2343.551 1822.186)) 5.400) "ETCH/BOTTOM" "PETN4_RECEPT") nc = nc + 1)
    when(axlDBCreatePath(axlPathStart(list(list(2343.551 1822.186) list(2353.551 1812.186)) 5.400) "ETCH/BOTTOM" "PETN4_RECEPT") nc = nc + 1)
    when(axlDBCreatePath(axlPathStart(list(list(2353.551 1812.186) list(2353.551 1800.586)) 5.400) "ETCH/BOTTOM" "PETN4_RECEPT") nc = nc + 1)
    when(axlDBCreatePath(axlPathStart(list(list(2353.551 1800.586) list(2343.551 1790.586)) 5.400) "ETCH/BOTTOM" "PETN4_RECEPT") nc = nc + 1)
    when(axlDBCreatePath(axlPathStart(list(list(2343.551 1790.586) list(2343.551 1778.986)) 5.400) "ETCH/BOTTOM" "PETN4_RECEPT") nc = nc + 1)
    when(axlDBCreatePath(axlPathStart(list(list(2343.551 1778.986) list(2353.551 1768.986)) 5.400) "ETCH/BOTTOM" "PETN4_RECEPT") nc = nc + 1)
    when(axlDBCreatePath(axlPathStart(list(list(2353.551 1768.986) list(2353.551 1757.386)) 5.400) "ETCH/BOTTOM" "PETN4_RECEPT") nc = nc + 1)
    when(axlDBCreatePath(axlPathStart(list(list(2353.551 1757.386) list(2343.551 1747.386)) 5.400) "ETCH/BOTTOM" "PETN4_RECEPT") nc = nc + 1)
    when(axlDBCreatePath(axlPathStart(list(list(2343.551 1747.386) list(2343.551 1735.786)) 5.400) "ETCH/BOTTOM" "PETN4_RECEPT") nc = nc + 1)
    when(axlDBCreatePath(axlPathStart(list(list(2343.551 1735.786) list(2353.551 1725.786)) 5.400) "ETCH/BOTTOM" "PETN4_RECEPT") nc = nc + 1)
    when(axlDBCreatePath(axlPathStart(list(list(2353.551 1725.786) list(2353.551 1714.186)) 5.400) "ETCH/BOTTOM" "PETN4_RECEPT") nc = nc + 1)
    when(axlDBCreatePath(axlPathStart(list(list(2353.551 1714.186) list(2343.551 1704.186)) 5.400) "ETCH/BOTTOM" "PETN4_RECEPT") nc = nc + 1)
    when(axlDBCreatePath(axlPathStart(list(list(2343.551 1704.186) list(2343.551 1692.586)) 5.400) "ETCH/BOTTOM" "PETN4_RECEPT") nc = nc + 1)
    when(axlDBCreatePath(axlPathStart(list(list(2343.551 1692.586) list(2353.551 1682.586)) 5.400) "ETCH/BOTTOM" "PETN4_RECEPT") nc = nc + 1)
    when(axlDBCreatePath(axlPathStart(list(list(2353.551 1682.586) list(2353.551 1670.986)) 5.400) "ETCH/BOTTOM" "PETN4_RECEPT") nc = nc + 1)
    when(axlDBCreatePath(axlPathStart(list(list(2353.551 1670.986) list(2343.551 1660.986)) 5.400) "ETCH/BOTTOM" "PETN4_RECEPT") nc = nc + 1)
    when(axlDBCreatePath(axlPathStart(list(list(2343.551 1660.986) list(2343.551 1633.256)) 5.400) "ETCH/BOTTOM" "PETN4_RECEPT") nc = nc + 1)
    when(axlDBCreatePath(axlPathStart(list(list(2343.551 1633.256) list(2354.551 1622.256)) 5.400) "ETCH/BOTTOM" "PETN4_RECEPT") nc = nc + 1)
    when(axlDBCreatePath(axlPathStart(list(list(2354.551 1622.256) list(2354.551 1615.401)) 5.400) "ETCH/BOTTOM" "PETN4_RECEPT") nc = nc + 1)
    when(axlDBCreatePath(axlPathStart(list(list(2354.551 1615.401) list(2362.606 1607.346)) 5.400) "ETCH/BOTTOM" "PETN4_RECEPT") nc = nc + 1)
    when(axlDBCreateVia("VIA10_20-FBD" list(2362.606 1607.346) "PETN4_RECEPT") nv = nv + 1)
    when(axlDBCreatePath(axlPathStart(list(list(2342.921 1587.661) list(2362.606 1607.346)) 5.000) "ETCH/TOP" "PETN4_RECEPT") nc = nc + 1)
    when(axlDBCreatePath(axlPathStart(list(list(2243.551 1212.701) list(2264.181 1233.331)) 4.000) "ETCH/TOP" "REFCLKOP_PHY0") nc = nc + 1)
    when(axlDBCreateVia("VIA10_20-FBD" list(1879.551 1864.693) "REFCLKOP_PHY1") nv = nv + 1)
    when(axlDBCreatePath(axlPathStart(list(list(2150.783 1862.389) list(2163.551 1862.389)) 4.000) "ETCH/BOTTOM" "REFCLKOP_PHY1") nc = nc + 1)
    when(axlDBCreateVia("VIA10_20-FBD" list(2201.794 1864.693) "REFCLKOP_PHY1") nv = nv + 1)
    when(axlDBCreatePath(axlPathStart(list(list(2264.181 1666.401) list(2245.051 1685.531)) 4.000) "ETCH/TOP" "REFCLKOP_PHY1") nc = nc + 1)
    when(axlDBCreatePath(axlPathStart(list(list(2245.051 1685.531) list(2245.051 1821.435)) 4.000) "ETCH/TOP" "REFCLKOP_PHY1") nc = nc + 1)
    when(axlDBCreatePath(axlPathStart(list(list(2245.051 1821.435) list(2203.035 1863.451)) 4.000) "ETCH/TOP" "REFCLKOP_PHY1") nc = nc + 1)
    when(axlDBCreatePath(axlPathStart(list(list(2203.035 1863.451) list(2203.035 1863.452)) 4.000) "ETCH/TOP" "REFCLKOP_PHY1") nc = nc + 1)
    when(axlDBCreatePath(axlPathStart(list(list(2203.035 1863.452) list(2201.794 1864.693)) 4.000) "ETCH/TOP" "REFCLKOP_PHY1") nc = nc + 1)
    when(axlDBCreatePath(axlPathStart(list(list(2254.051 1130.287) list(2261.551 1137.787)) 4.000) "ETCH/TOP" "REFCLKON_PHY0") nc = nc + 1)
    when(axlDBCreatePath(axlPathStart(list(list(2261.551 1137.787) list(2261.551 1146.287)) 4.000) "ETCH/TOP" "REFCLKON_PHY0") nc = nc + 1)
    when(axlDBCreatePath(axlPathStart(list(list(2261.551 1146.287) list(2254.051 1153.787)) 4.000) "ETCH/TOP" "REFCLKON_PHY0") nc = nc + 1)
    when(axlDBCreatePath(axlPathStart(list(list(2254.051 1153.787) list(2254.051 1183.830)) 4.000) "ETCH/TOP" "REFCLKON_PHY0") nc = nc + 1)
    when(axlDBCreatePath(axlPathStart(list(list(2254.051 1183.830) list(2264.181 1193.960)) 4.000) "ETCH/TOP" "REFCLKON_PHY0") nc = nc + 1)
    when(axlDBCreatePath(axlPathStart(list(list(2264.181 1705.772) list(2255.551 1714.402)) 4.000) "ETCH/TOP" "REFCLKON_PHY1") nc = nc + 1)
    when(axlDBCreatePath(axlPathStart(list(list(2255.551 1714.402) list(2255.551 1825.785)) 4.000) "ETCH/TOP" "REFCLKON_PHY1") nc = nc + 1)
    when(axlDBCreatePath(axlPathStart(list(list(2255.551 1825.785) list(2220.551 1860.785)) 4.000) "ETCH/TOP" "REFCLKON_PHY1") nc = nc + 1)
    printf("fanout: vias=%d segs=%d\n" nv nc)
    list(nv nc)))

;; borra TODAS las clines y vias de la placa (deshacer)
procedure( fo_clear()
  let((l)
    l = nil
    foreach(n axlDBGetDesign()->nets foreach(b n->branches foreach(o b->children
      when(member(o->objType list("via" "path")) l = cons(o l)))))
    printf("borrando %d\n" length(l))
    axlDeleteObject(l)))
