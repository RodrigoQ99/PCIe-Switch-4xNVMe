;; move1.il -- generado por replace.py
procedure( mv_all()
  let((n)
    n = 0
    when(l2_mv("BD3" 1735.000 1440.000 0.0 nil) n = n + 1)
    when(l2_mv("BD6" 1265.000 745.000 0.0 nil) n = n + 1)
    when(l2_mv("BD7" 1560.000 660.000 0.0 nil) n = n + 1)
    when(l2_mv("BD8" 2705.000 2635.000 0.0 nil) n = n + 1)
    when(l2_mv("C119" 2750.000 1450.000 0.0 nil) n = n + 1)
    when(l2_mv("C127" 2755.000 1575.000 0.0 nil) n = n + 1)
    when(l2_mv("C135" 2745.000 1145.000 0.0 nil) n = n + 1)
    when(l2_mv("C138" 3105.000 1130.000 0.0 nil) n = n + 1)
    when(l2_mv("C139" 2450.000 1925.000 0.0 nil) n = n + 1)
    when(l2_mv("C155" 2745.000 1910.000 0.0 nil) n = n + 1)
    when(l2_mv("C160" 1815.000 1145.000 0.0 nil) n = n + 1)
    when(l2_mv("C163" 1770.000 1585.000 0.0 nil) n = n + 1)
    when(l2_mv("C28" 1750.000 1895.000 0.0 nil) n = n + 1)
    when(l2_mv("C741" 3211.000 520.000 90.0 t) n = n + 1)
    when(l2_mv("C742" 3172.000 520.000 90.0 t) n = n + 1)
    when(l2_mv("C751" 4156.000 520.000 90.0 t) n = n + 1)
    when(l2_mv("C752" 4117.000 520.000 90.0 t) n = n + 1)
    when(l2_mv("C761" 5101.000 520.000 90.0 t) n = n + 1)
    when(l2_mv("C762" 5062.000 520.000 90.0 t) n = n + 1)
    when(l2_mv("C771" 6046.000 520.000 90.0 t) n = n + 1)
    when(l2_mv("C772" 6007.000 520.000 90.0 t) n = n + 1)
    when(l2_mv("DS1" 1805.000 370.000 0.0 nil) n = n + 1)
    when(l2_mv("DS2" 1770.000 1250.000 0.0 nil) n = n + 1)
    when(l2_mv("DS3" 1980.000 975.000 0.0 nil) n = n + 1)
    when(l2_mv("DS4" 1760.000 485.000 0.0 nil) n = n + 1)
    when(l2_mv("DS5" 3095.000 825.000 0.0 nil) n = n + 1)
    when(l2_mv("Q1" 2785.000 1310.000 0.0 nil) n = n + 1)
    when(l2_mv("Q2" 1820.000 960.000 0.0 nil) n = n + 1)
    when(l2_mv("R157" 2845.000 1210.000 0.0 nil) n = n + 1)
    when(l2_mv("R158" 1825.000 1335.000 0.0 nil) n = n + 1)
    when(l2_mv("R159" 3093.000 520.000 90.0 t) n = n + 1)
    when(l2_mv("R160" 3132.000 520.000 90.0 t) n = n + 1)
    when(l2_mv("R51" 2765.000 1245.000 0.0 nil) n = n + 1)
    when(l2_mv("R52" 1820.000 1080.000 0.0 nil) n = n + 1)
    when(l2_mv("R88" 5967.000 520.000 90.0 t) n = n + 1)
    when(l2_mv("R89" 5928.000 520.000 90.0 t) n = n + 1)
    when(l2_mv("R90" 4983.000 520.000 90.0 t) n = n + 1)
    when(l2_mv("R91" 5022.000 520.000 90.0 t) n = n + 1)
    when(l2_mv("R92" 4038.000 520.000 90.0 t) n = n + 1)
    when(l2_mv("R93" 4077.000 520.000 90.0 t) n = n + 1)
    when(l2_mv("RD1" 2055.000 330.000 0.0 nil) n = n + 1)
    when(l2_mv("RD14" 2830.000 1130.000 0.0 nil) n = n + 1)
    when(l2_mv("RD15" 2905.000 1040.000 0.0 nil) n = n + 1)
    when(l2_mv("RD19" 2825.000 1045.000 0.0 nil) n = n + 1)
    when(l2_mv("RD85" 2070.000 470.000 0.0 nil) n = n + 1)
    when(l2_mv("RP10" 1820.000 875.000 0.0 nil) n = n + 1)
    when(l2_mv("RP11" 2995.000 1040.000 0.0 nil) n = n + 1)
    when(l2_mv("RP12" 2750.000 1045.000 0.0 nil) n = n + 1)
    when(l2_mv("RP176" 3050.000 980.000 0.0 nil) n = n + 1)
    when(l2_mv("RP25" 1915.000 455.000 0.0 nil) n = n + 1)
    when(l2_mv("RP8" 1995.000 450.000 0.0 nil) n = n + 1)
    printf("movidas %d\n" n) n))

procedure( mv_go()
  mv_all()
  axlSaveDesign(?noConfirm t)
  printf("DRC=%L\n" axlDRCUpdate(nil))
  axlSaveDesign(?noConfirm t)
  l2_dump("place7.txt"))
