;; up.il -- generado por up_route.py (ruteo upstream lanes 0-3)
procedure( up_del()
  let((l)
    l = nil
    foreach(n axlDBGetDesign()->nets
      when(member(n->name list("CREFCLKN" "CREFCLKP" "PERN0_RECEPT" "PERN1_RECEPT" "PERN2_RECEPT" "PERN3_RECEPT" "PERP0_RECEPT" "PERP1_RECEPT" "PERP2_RECEPT" "PERP3_RECEPT" "PETN0_P0" "PETN0_RECEPT" "PETN1_P0" "PETN1_RECEPT" "PETN2_P0" "PETN2_RECEPT" "PETN3_P0" "PETN3_RECEPT" "PETP0_P0" "PETP0_RECEPT" "PETP1_P0" "PETP1_RECEPT" "PETP2_P0" "PETP2_RECEPT" "PETP3_P0" "PETP3_RECEPT"))
        foreach(b n->branches foreach(o b->children
          when(o->objType == "path" && (rexMatchp("^PER" n->name) || o->layer == "ETCH/BOTTOM") l = cons(o l))))))
    printf("borrando %d clines\n" length(l))
    axlDeleteObject(l)))

procedure( up_add()
  let((n)
    n = 0
    when(axlDBCreatePath(axlPathStart(list(list(2342.921 1233.331) list(2323.236 1213.646) list(2323.236 1135.000) list(2323.236 872.722) list(2913.236 282.722) list(2913.236 75.000) list(2913.236 62.051) list(2900.585 49.400) list(2900.585 -39.365)) 5.400) "ETCH/TOP" "PERP3_RECEPT") n = n + 1)
    when(axlDBCreatePath(axlPathStart(list(list(2342.921 1193.960) list(2342.921 1149.000) list(2334.236 1140.315) list(2334.236 1135.000) list(2334.236 877.278) list(2924.236 287.278) list(2924.236 75.000) list(2924.236 65.119) list(2939.955 49.400) list(2939.955 -39.365)) 5.400) "ETCH/TOP" "PERN3_RECEPT") n = n + 1)
    when(axlDBCreatePath(axlPathStart(list(list(2303.551 1233.331) list(2283.866 1213.646) list(2283.866 1135.000) list(2283.866 872.722) list(2758.866 397.722) list(2758.866 75.000) list(2758.866 65.161) list(2743.105 49.400) list(2743.105 -39.365)) 5.400) "ETCH/TOP" "PERP2_RECEPT") n = n + 1)
    when(axlDBCreatePath(axlPathStart(list(list(2303.551 1193.960) list(2303.551 1149.000) list(2294.866 1140.315) list(2294.866 1135.000) list(2294.866 877.278) list(2769.866 402.278) list(2769.866 75.000) list(2769.866 62.009) list(2782.475 49.400) list(2782.475 -39.365)) 5.400) "ETCH/TOP" "PERN2_RECEPT") n = n + 1)
    when(axlDBCreatePath(axlPathStart(list(list(2224.811 1233.331) list(2205.126 1213.646) list(2205.126 1135.000) list(2205.126 902.722) list(2600.126 507.722) list(2600.126 75.000) list(2600.126 63.901) list(2585.625 49.400) list(2585.625 -39.365)) 5.400) "ETCH/TOP" "PERP1_RECEPT") n = n + 1)
    when(axlDBCreatePath(axlPathStart(list(list(2224.811 1193.960) list(2224.811 1149.000) list(2216.126 1140.315) list(2216.126 1135.000) list(2216.126 907.278) list(2611.126 512.278) list(2611.126 75.000) list(2611.126 63.269) list(2624.995 49.400) list(2624.995 -39.365)) 5.400) "ETCH/TOP" "PERN1_RECEPT") n = n + 1)
    when(axlDBCreatePath(axlPathStart(list(list(2185.441 1233.331) list(2165.756 1213.646) list(2165.756 1135.000) list(2165.756 827.722) list(2400.756 592.722) list(2400.756 75.000) list(2400.756 61.382) list(2388.774 49.400) list(2388.774 -39.365)) 5.400) "ETCH/TOP" "PERP0_RECEPT") n = n + 1)
    when(axlDBCreatePath(axlPathStart(list(list(2185.441 1193.960) list(2185.441 1149.000) list(2176.756 1140.315) list(2176.756 1135.000) list(2176.756 832.278) list(2411.756 597.278) list(2411.756 75.000) list(2411.756 65.788) list(2428.144 49.400) list(2428.144 -39.365)) 5.400) "ETCH/TOP" "PERN0_RECEPT") n = n + 1)
    when(axlDBCreatePath(axlPathStart(list(list(2362.602 1331.760) list(2345.551 1314.709) list(2345.551 1285.257) list(2334.551 1274.257) list(2334.551 1255.000) list(2334.551 1030.000) list(2334.551 1017.722) list(2877.773 474.500) list(2992.773 474.500) list(2994.551 472.722) list(2994.551 470.000) list(2994.551 430.090) list(2979.016 414.555)) 5.400) "ETCH/BOTTOM" "PETP3_RECEPT") n = n + 1)
    when(axlDBCreatePath(axlPathStart(list(list(2362.602 1292.390) list(2362.602 1286.751) list(2345.551 1269.700) list(2345.551 1255.000) list(2345.551 1030.000) list(2345.551 1022.278) list(2882.329 485.500) list(2997.329 485.500) list(3005.551 477.278) list(3005.551 470.000) list(3005.551 428.020) list(3019.016 414.555)) 5.400) "ETCH/BOTTOM" "PETN3_RECEPT") n = n + 1)
    when(axlDBCreatePath(axlPathStart(list(list(2323.231 1331.750) list(2303.551 1312.070) list(2303.551 1255.000) list(2303.551 1030.000) list(2303.551 1002.722) list(2833.551 472.722) list(2833.551 470.000) list(2833.551 426.570) list(2821.536 414.555)) 5.400) "ETCH/BOTTOM" "PETP2_RECEPT") n = n + 1)
    when(axlDBCreatePath(axlPathStart(list(list(2323.231 1292.380) list(2314.551 1284.980) list(2314.551 1255.000) list(2314.551 1030.000) list(2314.551 1007.278) list(2844.551 477.278) list(2844.551 470.000) list(2844.551 431.540) list(2861.536 414.555)) 5.400) "ETCH/BOTTOM" "PETN2_RECEPT") n = n + 1)
    when(axlDBCreatePath(axlPathStart(list(list(2205.126 1331.756) list(2183.551 1310.181) list(2183.551 1274.257) list(2175.551 1266.257) list(2175.551 1255.000) list(2175.551 1030.000) list(2175.551 987.722) list(2680.551 482.722) list(2680.551 470.000) list(2680.551 431.050) list(2664.056 414.555)) 5.400) "ETCH/BOTTOM" "PETP1_RECEPT") n = n + 1)
    when(axlDBCreatePath(axlPathStart(list(list(2205.126 1292.386) list(2205.126 1280.275) list(2186.551 1261.700) list(2186.551 1255.000) list(2186.551 1030.000) list(2186.551 992.278) list(2691.551 487.278) list(2691.551 470.000) list(2691.551 427.060) list(2704.056 414.555)) 5.400) "ETCH/BOTTOM" "PETN1_RECEPT") n = n + 1)
    when(axlDBCreatePath(axlPathStart(list(list(2165.756 1331.756) list(2143.551 1309.551) list(2143.551 1255.000) list(2143.551 1030.000) list(2143.551 852.722) list(2483.551 512.722) list(2483.551 470.000) list(2483.551 430.901) list(2467.205 414.555)) 5.400) "ETCH/BOTTOM" "PETP0_RECEPT") n = n + 1)
    when(axlDBCreatePath(axlPathStart(list(list(2165.756 1292.386) list(2154.551 1281.181) list(2154.551 1255.000) list(2154.551 1030.000) list(2154.551 857.278) list(2494.551 517.278) list(2494.551 470.000) list(2494.551 427.209) list(2507.205 414.555)) 5.400) "ETCH/BOTTOM" "PETN0_RECEPT") n = n + 1)
    when(axlDBCreatePath(axlPathStart(list(list(2467.514 -39.365) list(2467.514 49.432)) 5.400) "ETCH/BOTTOM" "PETP0_P0") n = n + 1)
    when(axlDBCreatePath(axlPathStart(list(list(2467.514 49.432) list(2481.705 63.623)) 5.400) "ETCH/BOTTOM" "PETP0_P0") n = n + 1)
    when(axlDBCreatePath(axlPathStart(list(list(2481.705 63.623) list(2481.705 360.677)) 5.400) "ETCH/BOTTOM" "PETP0_P0") n = n + 1)
    when(axlDBCreatePath(axlPathStart(list(list(2481.705 360.677) list(2467.205 375.177)) 5.400) "ETCH/BOTTOM" "PETP0_P0") n = n + 1)
    when(axlDBCreatePath(axlPathStart(list(list(2507.205 375.177) list(2492.705 360.677)) 5.400) "ETCH/BOTTOM" "PETN0_P0") n = n + 1)
    when(axlDBCreatePath(axlPathStart(list(list(2492.705 360.677) list(2492.705 63.611)) 5.400) "ETCH/BOTTOM" "PETN0_P0") n = n + 1)
    when(axlDBCreatePath(axlPathStart(list(list(2492.705 63.611) list(2506.885 49.431)) 5.400) "ETCH/BOTTOM" "PETN0_P0") n = n + 1)
    when(axlDBCreatePath(axlPathStart(list(list(2506.885 49.431) list(2506.885 -39.365)) 5.400) "ETCH/BOTTOM" "PETN0_P0") n = n + 1)
    when(axlDBCreatePath(axlPathStart(list(list(2664.365 -39.365) list(2664.365 49.432)) 5.400) "ETCH/BOTTOM" "PETP1_P0") n = n + 1)
    when(axlDBCreatePath(axlPathStart(list(list(2664.365 49.432) list(2678.556 63.623)) 5.400) "ETCH/BOTTOM" "PETP1_P0") n = n + 1)
    when(axlDBCreatePath(axlPathStart(list(list(2678.556 63.623) list(2678.556 360.677)) 5.400) "ETCH/BOTTOM" "PETP1_P0") n = n + 1)
    when(axlDBCreatePath(axlPathStart(list(list(2678.556 360.677) list(2664.056 375.177)) 5.400) "ETCH/BOTTOM" "PETP1_P0") n = n + 1)
    when(axlDBCreatePath(axlPathStart(list(list(2664.365 -39.365) list(2664.370 -39.370)) 5.000) "ETCH/BOTTOM" "PETP1_P0") n = n + 1)
    when(axlDBCreatePath(axlPathStart(list(list(2664.370 -39.370) list(2664.370 -39.360)) 5.000) "ETCH/BOTTOM" "PETP1_P0") n = n + 1)
    when(axlDBCreatePath(axlPathStart(list(list(2664.370 -39.360) list(2664.365 -39.365)) 5.000) "ETCH/BOTTOM" "PETP1_P0") n = n + 1)
    when(axlDBCreatePath(axlPathStart(list(list(2703.735 -39.365) list(2703.735 49.430)) 5.400) "ETCH/BOTTOM" "PETN1_P0") n = n + 1)
    when(axlDBCreatePath(axlPathStart(list(list(2703.735 49.430) list(2689.556 63.609)) 5.400) "ETCH/BOTTOM" "PETN1_P0") n = n + 1)
    when(axlDBCreatePath(axlPathStart(list(list(2689.556 63.609) list(2689.556 360.677)) 5.400) "ETCH/BOTTOM" "PETN1_P0") n = n + 1)
    when(axlDBCreatePath(axlPathStart(list(list(2689.556 360.677) list(2704.056 375.177)) 5.400) "ETCH/BOTTOM" "PETN1_P0") n = n + 1)
    when(axlDBCreatePath(axlPathStart(list(list(2821.845 -39.365) list(2821.845 49.432)) 5.400) "ETCH/BOTTOM" "PETP2_P0") n = n + 1)
    when(axlDBCreatePath(axlPathStart(list(list(2821.845 49.432) list(2836.036 63.623)) 5.400) "ETCH/BOTTOM" "PETP2_P0") n = n + 1)
    when(axlDBCreatePath(axlPathStart(list(list(2836.036 63.623) list(2836.036 360.677)) 5.400) "ETCH/BOTTOM" "PETP2_P0") n = n + 1)
    when(axlDBCreatePath(axlPathStart(list(list(2836.036 360.677) list(2821.536 375.177)) 5.400) "ETCH/BOTTOM" "PETP2_P0") n = n + 1)
    when(axlDBCreatePath(axlPathStart(list(list(2861.215 -39.365) list(2861.215 49.432)) 5.400) "ETCH/BOTTOM" "PETN2_P0") n = n + 1)
    when(axlDBCreatePath(axlPathStart(list(list(2861.215 49.432) list(2847.036 63.611)) 5.400) "ETCH/BOTTOM" "PETN2_P0") n = n + 1)
    when(axlDBCreatePath(axlPathStart(list(list(2847.036 63.611) list(2847.036 360.677)) 5.400) "ETCH/BOTTOM" "PETN2_P0") n = n + 1)
    when(axlDBCreatePath(axlPathStart(list(list(2847.036 360.677) list(2861.536 375.177)) 5.400) "ETCH/BOTTOM" "PETN2_P0") n = n + 1)
    when(axlDBCreatePath(axlPathStart(list(list(2979.325 -39.365) list(2979.325 49.432)) 5.400) "ETCH/BOTTOM" "PETP3_P0") n = n + 1)
    when(axlDBCreatePath(axlPathStart(list(list(2979.325 49.432) list(2993.516 63.623)) 5.400) "ETCH/BOTTOM" "PETP3_P0") n = n + 1)
    when(axlDBCreatePath(axlPathStart(list(list(2993.516 63.623) list(2993.516 360.677)) 5.400) "ETCH/BOTTOM" "PETP3_P0") n = n + 1)
    when(axlDBCreatePath(axlPathStart(list(list(2993.516 360.677) list(2979.016 375.177)) 5.400) "ETCH/BOTTOM" "PETP3_P0") n = n + 1)
    when(axlDBCreatePath(axlPathStart(list(list(3019.016 375.177) list(3004.516 360.677)) 5.400) "ETCH/BOTTOM" "PETN3_P0") n = n + 1)
    when(axlDBCreatePath(axlPathStart(list(list(3004.516 360.677) list(3004.516 63.611)) 5.400) "ETCH/BOTTOM" "PETN3_P0") n = n + 1)
    when(axlDBCreatePath(axlPathStart(list(list(3004.516 63.611) list(3018.696 49.431)) 5.400) "ETCH/BOTTOM" "PETN3_P0") n = n + 1)
    when(axlDBCreatePath(axlPathStart(list(list(3018.696 49.431) list(3018.696 -39.365)) 5.400) "ETCH/BOTTOM" "PETN3_P0") n = n + 1)
    when(axlDBCreatePath(axlPathStart(list(list(2349.404 -39.365) list(2349.404 49.141)) 4.000) "ETCH/BOTTOM" "CREFCLKP") n = n + 1)
    when(axlDBCreatePath(axlPathStart(list(list(2349.404 49.141) list(2363.839 63.576)) 4.000) "ETCH/BOTTOM" "CREFCLKP") n = n + 1)
    when(axlDBCreatePath(axlPathStart(list(list(2363.839 63.576) list(2363.839 360.427)) 4.000) "ETCH/BOTTOM" "CREFCLKP") n = n + 1)
    when(axlDBCreatePath(axlPathStart(list(list(2363.839 360.427) list(2349.089 375.177)) 4.000) "ETCH/BOTTOM" "CREFCLKP") n = n + 1)
    when(axlDBCreatePath(axlPathStart(list(list(2389.089 375.177) list(2374.339 360.427)) 4.000) "ETCH/BOTTOM" "CREFCLKN") n = n + 1)
    when(axlDBCreatePath(axlPathStart(list(list(2374.339 360.427) list(2374.339 63.576)) 4.000) "ETCH/BOTTOM" "CREFCLKN") n = n + 1)
    when(axlDBCreatePath(axlPathStart(list(list(2374.339 63.576) list(2388.774 49.141)) 4.000) "ETCH/BOTTOM" "CREFCLKN") n = n + 1)
    when(axlDBCreatePath(axlPathStart(list(list(2388.774 49.141) list(2388.774 -39.365)) 4.000) "ETCH/BOTTOM" "CREFCLKN") n = n + 1)
    printf("paths %d\n" n) n))

procedure( up_go()
  axlCNSSetPhysical("DIFF_85OHM" nil 'dp_coupled_plus 0.5)
  axlCNSSetPhysical("DIFF_85OHM" nil 'dp_coupled_minus 0.5)
  up_del() up_add()
  axlSaveDesign(?noConfirm t)
  printf("DRC=%L\n" axlDRCUpdate(nil))
  axlSaveDesign(?noConfirm t)
  l2_dump("place11.txt"))
